* NGSPICE file created from tg_x0p25_mf.ext - technology: sky130A

.subckt sky130_fd_pr__nfet_g5v0d10v5_XX2EF7 B D S G
X0 S G D B sky130_fd_pr__nfet_g5v0d10v5 ad=0.58 pd=4.58 as=0.58 ps=4.58 w=2 l=0.5
.ends

.subckt sky130_fd_pr__pfet_g5v0d10v5_DCBGND B D0 G S1 D2 S2
X0 S1 G D0 B sky130_fd_pr__pfet_g5v0d10v5 ad=0.29 pd=2.29 as=0.58 ps=4.58 w=2 l=0.5
X1 S2 G D2 B sky130_fd_pr__pfet_g5v0d10v5 ad=0.58 pd=4.58 as=0.29 ps=2.29 w=2 l=0.5
X2 D2 G S1 B sky130_fd_pr__pfet_g5v0d10v5 ad=0.29 pd=2.29 as=0.29 ps=2.29 w=2 l=0.5
.ends

.subckt tg_x0p25_mf a b en enb vss vdd
Xmn vss a b en sky130_fd_pr__nfet_g5v0d10v5_XX2EF7
Xmp vdd a enb b a b sky130_fd_pr__pfet_g5v0d10v5_DCBGND
.ends
