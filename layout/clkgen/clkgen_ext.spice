* NGSPICE file created from clkgen.ext - technology: sky130A

.subckt sky130_fd_pr__cap_mim_m3_1_64QFDR C2 C1
X0 C1 C2 sky130_fd_pr__cap_mim_m3_1 l=5.32 w=5.32
.ends

.subckt sky130_fd_pr__pfet_g5v0d10v5_QUWD6C B D S G
X0 S G D B sky130_fd_pr__pfet_g5v0d10v5 ad=3.48 pd=24.58 as=3.48 ps=24.58 w=12 l=0.5
.ends

.subckt sky130_fd_pr__pfet_g5v0d10v5_FKTA3B B D0 G0 S1 G1 a_129_n1200#
X0 S1 G0 D0 B sky130_fd_pr__pfet_g5v0d10v5 ad=1.74 pd=12.29 as=3.48 ps=24.58 w=12 l=0.5
X1 a_129_n1200# G1 S1 B sky130_fd_pr__pfet_g5v0d10v5 ad=3.48 pd=24.58 as=1.74 ps=12.29 w=12 l=0.5
.ends

.subckt sky130_fd_pr__pfet_g5v0d10v5_P2LHF6 B D0 G0 S1 G1 a_829_n200#
X0 S1 G0 D0 B sky130_fd_pr__pfet_g5v0d10v5 ad=0.29 pd=2.29 as=0.58 ps=4.58 w=2 l=4
X1 a_829_n200# G1 S1 B sky130_fd_pr__pfet_g5v0d10v5 ad=0.58 pd=4.58 as=0.29 ps=2.29 w=2 l=4
.ends

.subckt sky130_fd_pr__nfet_g5v0d10v5_HKK92S B D0 G0 S1 G1 a_829_n100#
X0 a_829_n100# G1 S1 B sky130_fd_pr__nfet_g5v0d10v5 ad=0.29 pd=2.58 as=0.145 ps=1.29 w=1 l=4
X1 S1 G0 D0 B sky130_fd_pr__nfet_g5v0d10v5 ad=0.145 pd=1.29 as=0.29 ps=2.58 w=1 l=4
.ends

.subckt sky130_fd_pr__nfet_g5v0d10v5_2PPV84 B D S G
X0 S G D B sky130_fd_pr__nfet_g5v0d10v5 ad=1.16 pd=8.58 as=1.16 ps=8.58 w=4 l=0.5
.ends

.subckt sky130_fd_pr__nfet_g5v0d10v5_YJRXUS B D S G
X0 S G D B sky130_fd_pr__nfet_g5v0d10v5 ad=2.32 pd=16.58 as=2.32 ps=16.58 w=8 l=0.5
.ends

.subckt sky130_fd_pr__cap_mim_m3_1_MHCNCU C2 C1
X0 C1 C2 sky130_fd_pr__cap_mim_m3_1 l=3 w=3
.ends

.subckt sky130_fd_pr__pfet_g5v0d10v5_99RJQ2 B D S G
X0 S G D B sky130_fd_pr__pfet_g5v0d10v5 ad=1.74 pd=12.58 as=1.74 ps=12.58 w=6 l=0.5
.ends

.subckt sky130_fd_pr__pfet_g5v0d10v5_P7LTMB B D0 G0 S1 G1 a_129_n600#
X0 a_129_n600# G1 S1 B sky130_fd_pr__pfet_g5v0d10v5 ad=1.74 pd=12.58 as=0.87 ps=6.29 w=6 l=0.5
X1 S1 G0 D0 B sky130_fd_pr__pfet_g5v0d10v5 ad=0.87 pd=6.29 as=1.74 ps=12.58 w=6 l=0.5
.ends

.subckt sky130_fd_pr__nfet_g5v0d10v5_9BDQA4 B D S G
X0 S G D B sky130_fd_pr__nfet_g5v0d10v5 ad=0.58 pd=4.58 as=0.58 ps=4.58 w=2 l=0.5
.ends

.subckt sky130_fd_pr__nfet_g5v0d10v5_WB2VJZ B D0 G0 S1 G1 a_129_n200#
X0 a_129_n200# G1 S1 B sky130_fd_pr__nfet_g5v0d10v5 ad=0.58 pd=4.58 as=0.29 ps=2.29 w=2 l=0.5
X1 S1 G0 D0 B sky130_fd_pr__nfet_g5v0d10v5 ad=0.29 pd=2.29 as=0.58 ps=4.58 w=2 l=0.5
.ends

.subckt sky130_fd_pr__nfet_g5v0d10v5_KYRSGX B D0 G0 S1 G1 a_129_n400#
X0 S1 G0 D0 B sky130_fd_pr__nfet_g5v0d10v5 ad=0.58 pd=4.29 as=1.16 ps=8.58 w=4 l=0.5
X1 a_129_n400# G1 S1 B sky130_fd_pr__nfet_g5v0d10v5 ad=1.16 pd=8.58 as=0.58 ps=4.29 w=4 l=0.5
.ends

.subckt clkgen gnd p1 cc p1a clk p2 p1ab p1b p2b vdda
Xc_XCgdc_1 gnd p_dc23/G0 sky130_fd_pr__cap_mim_m3_1_64QFDR
Xp_a1 vdda p_a1/D vdda p_a1/G sky130_fd_pr__pfet_g5v0d10v5_QUWD6C
Xp_a2 vdda p1a p_a1/D vdda p_a1/D p1a sky130_fd_pr__pfet_g5v0d10v5_FKTA3B
Xp_b2 vdda p2 p_b1/D vdda p_b1/D p2 sky130_fd_pr__pfet_g5v0d10v5_FKTA3B
Xp_b3 vdda p2b p2 vdda p2 p2b sky130_fd_pr__pfet_g5v0d10v5_FKTA3B
Xp_dg2 vdda p_dg2/G1 p2 vdda p_dg2/G1 p_n1/G1 sky130_fd_pr__pfet_g5v0d10v5_P2LHF6
Xn_dc01 gnd p_dc01/G1 p1a gnd p_dc01/G1 p_dc23/G0 sky130_fd_pr__nfet_g5v0d10v5_HKK92S
Xn_dc23 gnd p_dc23/G1 p_dc23/G0 gnd p_dc23/G1 p_cn/G1 sky130_fd_pr__nfet_g5v0d10v5_HKK92S
Xp_a3 vdda p1ab p1a vdda p1a p1ab sky130_fd_pr__pfet_g5v0d10v5_FKTA3B
Xc_XCgdc_2 gnd p_dc23/G1 sky130_fd_pr__cap_mim_m3_1_64QFDR
Xc_XCgdc_3 gnd p_cn/G1 sky130_fd_pr__cap_mim_m3_1_64QFDR
Xn_e1 gnd p_e1/D gnd p_e1/G sky130_fd_pr__nfet_g5v0d10v5_2PPV84
Xn_e2 gnd p1 gnd p_e1/D sky130_fd_pr__nfet_g5v0d10v5_YJRXUS
Xn_e3 gnd p1b gnd p1 sky130_fd_pr__nfet_g5v0d10v5_YJRXUS
Xp_cb vdda cc vdda p_cb/G sky130_fd_pr__pfet_g5v0d10v5_QUWD6C
Xn_b1 gnd p_b1/D gnd p_b1/G sky130_fd_pr__nfet_g5v0d10v5_2PPV84
Xn_a1 gnd p_a1/D gnd p_a1/G sky130_fd_pr__nfet_g5v0d10v5_2PPV84
Xn_b2 gnd p2 gnd p_b1/D sky130_fd_pr__nfet_g5v0d10v5_YJRXUS
Xp_de vdda p_de/G1 p1a vdda p_de/G1 p_e1/G sky130_fd_pr__pfet_g5v0d10v5_P2LHF6
Xn_a2 gnd p1a gnd p_a1/D sky130_fd_pr__nfet_g5v0d10v5_YJRXUS
Xn_b3 gnd p2b gnd p2 sky130_fd_pr__nfet_g5v0d10v5_YJRXUS
Xp_dc01 vdda p_dc01/G1 p1a vdda p_dc01/G1 p_dc23/G0 sky130_fd_pr__pfet_g5v0d10v5_P2LHF6
Xp_dc23 vdda p_dc23/G1 p_dc23/G0 vdda p_dc23/G1 p_cn/G1 sky130_fd_pr__pfet_g5v0d10v5_P2LHF6
Xc_XCgdg2_0 gnd p_dg2/G1 sky130_fd_pr__cap_mim_m3_1_MHCNCU
Xn_a3 gnd p1ab gnd p1a sky130_fd_pr__nfet_g5v0d10v5_YJRXUS
Xc_XCgdg2_1 gnd p_n1/G1 sky130_fd_pr__cap_mim_m3_1_MHCNCU
Xp_ck vdda p_ck/D vdda clk sky130_fd_pr__pfet_g5v0d10v5_99RJQ2
Xn_dg1 gnd p_dg1/G1 p1 gnd p_dg1/G1 p_n2/G1 sky130_fd_pr__nfet_g5v0d10v5_HKK92S
Xn_dg2 gnd p_dg2/G1 p2 gnd p_dg2/G1 p_n1/G1 sky130_fd_pr__nfet_g5v0d10v5_HKK92S
Xp_n1 vdda vdda p_ck/D p_n1/S1 p_n1/G1 p_a1/G sky130_fd_pr__pfet_g5v0d10v5_FKTA3B
Xp_cn vdda vdda p1a p_cb/G p_cn/G1 vdda sky130_fd_pr__pfet_g5v0d10v5_P7LTMB
Xn_cb gnd cc gnd p_cb/G sky130_fd_pr__nfet_g5v0d10v5_2PPV84
Xp_n2 vdda vdda clk p_n2/S1 p_n2/G1 p_b1/G sky130_fd_pr__pfet_g5v0d10v5_FKTA3B
Xn_de gnd p_de/G1 p1a gnd p_de/G1 p_e1/G sky130_fd_pr__nfet_g5v0d10v5_HKK92S
Xp_e1 vdda p_e1/D vdda p_e1/G sky130_fd_pr__pfet_g5v0d10v5_QUWD6C
Xc_XCgde_0 gnd p_de/G1 sky130_fd_pr__cap_mim_m3_1_MHCNCU
Xn_ck gnd p_ck/D gnd clk sky130_fd_pr__nfet_g5v0d10v5_9BDQA4
Xc_XCgde_1 gnd p_e1/G sky130_fd_pr__cap_mim_m3_1_MHCNCU
Xp_e2 vdda p1 p_e1/D vdda p_e1/D p1 sky130_fd_pr__pfet_g5v0d10v5_FKTA3B
Xc_XCgdg1_0 gnd p_dg1/G1 sky130_fd_pr__cap_mim_m3_1_MHCNCU
Xc_XCgdg1_1 gnd p_n2/G1 sky130_fd_pr__cap_mim_m3_1_MHCNCU
Xp_e3 vdda p1b p1 vdda p1 p1b sky130_fd_pr__pfet_g5v0d10v5_FKTA3B
Xn_n1 gnd gnd p_ck/D p_a1/G p_n1/G1 gnd sky130_fd_pr__nfet_g5v0d10v5_WB2VJZ
Xn_cn gnd p_cb/G p1a n_cn/S1 p_cn/G1 gnd sky130_fd_pr__nfet_g5v0d10v5_KYRSGX
Xp_dg1 vdda p_dg1/G1 p1 vdda p_dg1/G1 p_n2/G1 sky130_fd_pr__pfet_g5v0d10v5_P2LHF6
Xp_b1 vdda p_b1/D vdda p_b1/G sky130_fd_pr__pfet_g5v0d10v5_QUWD6C
Xc_XCgdc_0 gnd p_dc01/G1 sky130_fd_pr__cap_mim_m3_1_64QFDR
Xn_n2 gnd gnd clk p_b1/G p_n2/G1 gnd sky130_fd_pr__nfet_g5v0d10v5_WB2VJZ
.ends
