* NGSPICE file created from clkgen.ext - technology: sky130A

.subckt sky130_fd_pr__cap_mim_m3_1_64QFDR C2 C1 w_n748_n572#
X0 C1 C2 sky130_fd_pr__cap_mim_m3_1 l=5.32 w=5.32
C0 C1 w_n748_n572# 0.86551f
C1 C2 w_n748_n572# 1.95264f
.ends

.subckt sky130_fd_pr__pfet_g5v0d10v5_QUWD6C B D S G VSUBS
X0 S G D B sky130_fd_pr__pfet_g5v0d10v5 ad=3.48 pd=24.58 as=3.48 ps=24.58 w=12 l=0.5
C0 S VSUBS 1.89237f
C1 D VSUBS 1.89237f
C2 G VSUBS 0.39607f
C3 B VSUBS 8.00609f
.ends

.subckt sky130_fd_pr__pfet_g5v0d10v5_FKTA3B B D0 G0 S1 G1 a_129_n1200# VSUBS
X0 S1 G0 D0 B sky130_fd_pr__pfet_g5v0d10v5 ad=1.74 pd=12.29 as=3.48 ps=24.58 w=12 l=0.5
X1 a_129_n1200# G1 S1 B sky130_fd_pr__pfet_g5v0d10v5 ad=3.48 pd=24.58 as=1.74 ps=12.29 w=12 l=0.5
C0 S1 VSUBS 1.89237f
C1 D0 VSUBS 1.89237f
C2 G1 VSUBS 0.39607f
C3 G0 VSUBS 0.39607f
C4 B VSUBS 9.54622f
C5 a_129_n1200# VSUBS 1.89237f
.ends

.subckt sky130_fd_pr__pfet_g5v0d10v5_P2LHF6 B D0 G0 S1 G1 a_829_n200# VSUBS
X0 S1 G0 D0 B sky130_fd_pr__pfet_g5v0d10v5 ad=0.29 pd=2.29 as=0.58 ps=4.58 w=2 l=4
X1 a_829_n200# G1 S1 B sky130_fd_pr__pfet_g5v0d10v5 ad=0.58 pd=4.58 as=0.29 ps=2.29 w=2 l=4
C0 S1 VSUBS 0.3418f
C1 D0 VSUBS 0.3418f
C2 G1 VSUBS 2.17109f
C3 G0 VSUBS 2.17109f
C4 B VSUBS 8.61761f
C5 a_829_n200# VSUBS 0.3418f
.ends

.subckt sky130_fd_pr__nfet_g5v0d10v5_HKK92S B D0 G0 S1 G1 a_829_n100#
X0 a_829_n100# G1 S1 B sky130_fd_pr__nfet_g5v0d10v5 ad=0.29 pd=2.58 as=0.145 ps=1.29 w=1 l=4
X1 S1 G0 D0 B sky130_fd_pr__nfet_g5v0d10v5 ad=0.145 pd=1.29 as=0.29 ps=2.58 w=1 l=4
C0 S1 B 0.18675f
C1 D0 B 0.18675f
C2 G1 B 2.12449f
C3 G0 B 2.12449f
C4 a_829_n100# B 0.18675f
.ends

.subckt sky130_fd_pr__nfet_g5v0d10v5_2PPV84 B D S G
X0 S G D B sky130_fd_pr__nfet_g5v0d10v5 ad=1.16 pd=8.58 as=1.16 ps=8.58 w=4 l=0.5
C0 S B 0.65192f
C1 D B 0.65192f
C2 G B 0.38281f
.ends

.subckt sky130_fd_pr__nfet_g5v0d10v5_YJRXUS B D S G
X0 S G D B sky130_fd_pr__nfet_g5v0d10v5 ad=2.32 pd=16.58 as=2.32 ps=16.58 w=8 l=0.5
C0 S B 1.27215f
C1 D B 1.27215f
C2 G B 0.38281f
.ends

.subckt sky130_fd_pr__cap_mim_m3_1_MHCNCU C2 C1 w_n516_n340#
X0 C1 C2 sky130_fd_pr__cap_mim_m3_1 l=3 w=3
C0 C1 w_n516_n340# 0.40279f
C1 C2 w_n516_n340# 1.11719f
.ends

.subckt sky130_fd_pr__pfet_g5v0d10v5_99RJQ2 B D S G VSUBS
X0 S G D B sky130_fd_pr__pfet_g5v0d10v5 ad=1.74 pd=12.58 as=1.74 ps=12.58 w=6 l=0.5
C0 S VSUBS 0.96203f
C1 D VSUBS 0.96203f
C2 G VSUBS 0.39607f
C3 B VSUBS 4.86966f
.ends

.subckt sky130_fd_pr__pfet_g5v0d10v5_P7LTMB B D0 G0 S1 G1 a_129_n600# VSUBS
X0 a_129_n600# G1 S1 B sky130_fd_pr__pfet_g5v0d10v5 ad=1.74 pd=12.58 as=0.87 ps=6.29 w=6 l=0.5
X1 S1 G0 D0 B sky130_fd_pr__pfet_g5v0d10v5 ad=0.87 pd=6.29 as=1.74 ps=12.58 w=6 l=0.5
C0 S1 VSUBS 0.96203f
C1 D0 VSUBS 0.96203f
C2 G1 VSUBS 0.39607f
C3 G0 VSUBS 0.39607f
C4 B VSUBS 5.841f
C5 a_129_n600# VSUBS 0.96203f
.ends

.subckt sky130_fd_pr__nfet_g5v0d10v5_9BDQA4 B D S G
X0 S G D B sky130_fd_pr__nfet_g5v0d10v5 ad=0.58 pd=4.58 as=0.58 ps=4.58 w=2 l=0.5
C0 S B 0.3418f
C1 D B 0.3418f
C2 G B 0.38281f
.ends

.subckt sky130_fd_pr__nfet_g5v0d10v5_WB2VJZ B D0 G0 S1 G1 a_129_n200#
X0 a_129_n200# G1 S1 B sky130_fd_pr__nfet_g5v0d10v5 ad=0.58 pd=4.58 as=0.29 ps=2.29 w=2 l=0.5
X1 S1 G0 D0 B sky130_fd_pr__nfet_g5v0d10v5 ad=0.29 pd=2.29 as=0.58 ps=4.58 w=2 l=0.5
C0 S1 B 0.3418f
C1 D0 B 0.3418f
C2 G1 B 0.38281f
C3 G0 B 0.38281f
C4 a_129_n200# B 0.3418f
.ends

.subckt sky130_fd_pr__nfet_g5v0d10v5_KYRSGX B D0 G0 S1 G1 a_129_n400#
X0 S1 G0 D0 B sky130_fd_pr__nfet_g5v0d10v5 ad=0.58 pd=4.29 as=1.16 ps=8.58 w=4 l=0.5
X1 a_129_n400# G1 S1 B sky130_fd_pr__nfet_g5v0d10v5 ad=1.16 pd=8.58 as=0.58 ps=4.29 w=4 l=0.5
C0 S1 B 0.65192f
C1 D0 B 0.65192f
C2 G1 B 0.38281f
C3 G0 B 0.38281f
C4 a_129_n400# B 0.65192f
.ends

.subckt clkgen gnd p1 cc p1a clk p2 p1ab p1b p2b vdda
Xc_XCgdc_1 gnd p_dc23/G0 gnd sky130_fd_pr__cap_mim_m3_1_64QFDR
Xp_a1 vdda p_a1/D vdda p_a1/G gnd sky130_fd_pr__pfet_g5v0d10v5_QUWD6C
Xp_a2 vdda p1a p_a1/D vdda p_a1/D p1a gnd sky130_fd_pr__pfet_g5v0d10v5_FKTA3B
Xp_b2 vdda p2 p_b1/D vdda p_b1/D p2 gnd sky130_fd_pr__pfet_g5v0d10v5_FKTA3B
Xp_b3 vdda p2b p2 vdda p2 p2b gnd sky130_fd_pr__pfet_g5v0d10v5_FKTA3B
Xp_dg2 vdda p_dg2/G1 p2 vdda p_dg2/G1 p_n1/G1 gnd sky130_fd_pr__pfet_g5v0d10v5_P2LHF6
Xn_dc01 gnd p_dc01/G1 p1a gnd p_dc01/G1 p_dc23/G0 sky130_fd_pr__nfet_g5v0d10v5_HKK92S
Xn_dc23 gnd p_dc23/G1 p_dc23/G0 gnd p_dc23/G1 p_cn/G1 sky130_fd_pr__nfet_g5v0d10v5_HKK92S
Xp_a3 vdda p1ab p1a vdda p1a p1ab gnd sky130_fd_pr__pfet_g5v0d10v5_FKTA3B
Xc_XCgdc_2 gnd p_dc23/G1 gnd sky130_fd_pr__cap_mim_m3_1_64QFDR
Xc_XCgdc_3 gnd p_cn/G1 gnd sky130_fd_pr__cap_mim_m3_1_64QFDR
Xn_e1 gnd p_e1/D gnd p_e1/G sky130_fd_pr__nfet_g5v0d10v5_2PPV84
Xn_e2 gnd p1 gnd p_e1/D sky130_fd_pr__nfet_g5v0d10v5_YJRXUS
Xn_e3 gnd p1b gnd p1 sky130_fd_pr__nfet_g5v0d10v5_YJRXUS
Xp_cb vdda cc vdda p_cb/G gnd sky130_fd_pr__pfet_g5v0d10v5_QUWD6C
Xn_b1 gnd p_b1/D gnd p_b1/G sky130_fd_pr__nfet_g5v0d10v5_2PPV84
Xn_a1 gnd p_a1/D gnd p_a1/G sky130_fd_pr__nfet_g5v0d10v5_2PPV84
Xn_b2 gnd p2 gnd p_b1/D sky130_fd_pr__nfet_g5v0d10v5_YJRXUS
Xp_de vdda p_de/G1 p1a vdda p_de/G1 p_e1/G gnd sky130_fd_pr__pfet_g5v0d10v5_P2LHF6
Xn_a2 gnd p1a gnd p_a1/D sky130_fd_pr__nfet_g5v0d10v5_YJRXUS
Xn_b3 gnd p2b gnd p2 sky130_fd_pr__nfet_g5v0d10v5_YJRXUS
Xp_dc01 vdda p_dc01/G1 p1a vdda p_dc01/G1 p_dc23/G0 gnd sky130_fd_pr__pfet_g5v0d10v5_P2LHF6
Xp_dc23 vdda p_dc23/G1 p_dc23/G0 vdda p_dc23/G1 p_cn/G1 gnd sky130_fd_pr__pfet_g5v0d10v5_P2LHF6
Xc_XCgdg2_0 gnd p_dg2/G1 gnd sky130_fd_pr__cap_mim_m3_1_MHCNCU
Xn_a3 gnd p1ab gnd p1a sky130_fd_pr__nfet_g5v0d10v5_YJRXUS
Xc_XCgdg2_1 gnd p_n1/G1 gnd sky130_fd_pr__cap_mim_m3_1_MHCNCU
Xp_ck vdda p_ck/D vdda clk gnd sky130_fd_pr__pfet_g5v0d10v5_99RJQ2
Xn_dg1 gnd p_dg1/G1 p1 gnd p_dg1/G1 p_n2/G1 sky130_fd_pr__nfet_g5v0d10v5_HKK92S
Xn_dg2 gnd p_dg2/G1 p2 gnd p_dg2/G1 p_n1/G1 sky130_fd_pr__nfet_g5v0d10v5_HKK92S
Xp_n1 vdda vdda p_ck/D p_n1/S1 p_n1/G1 p_a1/G gnd sky130_fd_pr__pfet_g5v0d10v5_FKTA3B
Xp_cn vdda vdda p1a p_cb/G p_cn/G1 vdda gnd sky130_fd_pr__pfet_g5v0d10v5_P7LTMB
Xn_cb gnd cc gnd p_cb/G sky130_fd_pr__nfet_g5v0d10v5_2PPV84
Xp_n2 vdda vdda clk p_n2/S1 p_n2/G1 p_b1/G gnd sky130_fd_pr__pfet_g5v0d10v5_FKTA3B
Xn_de gnd p_de/G1 p1a gnd p_de/G1 p_e1/G sky130_fd_pr__nfet_g5v0d10v5_HKK92S
Xp_e1 vdda p_e1/D vdda p_e1/G gnd sky130_fd_pr__pfet_g5v0d10v5_QUWD6C
Xc_XCgde_0 gnd p_de/G1 gnd sky130_fd_pr__cap_mim_m3_1_MHCNCU
Xn_ck gnd p_ck/D gnd clk sky130_fd_pr__nfet_g5v0d10v5_9BDQA4
Xc_XCgde_1 gnd p_e1/G gnd sky130_fd_pr__cap_mim_m3_1_MHCNCU
Xp_e2 vdda p1 p_e1/D vdda p_e1/D p1 gnd sky130_fd_pr__pfet_g5v0d10v5_FKTA3B
Xc_XCgdg1_0 gnd p_dg1/G1 gnd sky130_fd_pr__cap_mim_m3_1_MHCNCU
Xc_XCgdg1_1 gnd p_n2/G1 gnd sky130_fd_pr__cap_mim_m3_1_MHCNCU
Xp_e3 vdda p1b p1 vdda p1 p1b gnd sky130_fd_pr__pfet_g5v0d10v5_FKTA3B
Xn_n1 gnd gnd p_ck/D p_a1/G p_n1/G1 gnd sky130_fd_pr__nfet_g5v0d10v5_WB2VJZ
Xn_cn gnd p_cb/G p1a n_cn/S1 p_cn/G1 gnd sky130_fd_pr__nfet_g5v0d10v5_KYRSGX
Xp_dg1 vdda p_dg1/G1 p1 vdda p_dg1/G1 p_n2/G1 gnd sky130_fd_pr__pfet_g5v0d10v5_P2LHF6
Xp_b1 vdda p_b1/D vdda p_b1/G gnd sky130_fd_pr__pfet_g5v0d10v5_QUWD6C
Xc_XCgdc_0 gnd p_dc01/G1 gnd sky130_fd_pr__cap_mim_m3_1_64QFDR
Xn_n2 gnd gnd clk p_b1/G p_n2/G1 gnd sky130_fd_pr__nfet_g5v0d10v5_WB2VJZ
C0 p_b1/G gnd 7.21404f
C1 p_n2/G1 gnd 13.5034f
C2 p_cb/G gnd 6.05223f
C3 p_a1/G gnd 7.06981f
C4 p_ck/D gnd 6.14683f
C5 clk gnd 12.2665f
C6 p_de/G1 gnd 14.3913f
C7 p_e1/G gnd 17.815f
C8 cc gnd 4.31536f
C9 p_dg2/G1 gnd 13.1322f
C10 p2 gnd 14.3787f
C11 p_n1/G1 gnd 16.0809f
C12 p_dg1/G1 gnd 12.4831f
C13 p1 gnd 23.2593f
C14 p1ab gnd 12.0074f
C15 p2b gnd 6.59452f
C16 p_a1/D gnd 9.27529f
C17 p_b1/D gnd 6.47124f
C18 vdda gnd 57.5749f
C19 p1b gnd 14.8832f
C20 p_e1/D gnd 9.07218f
C21 p_dc23/G1 gnd 17.9417f
C22 p_dc23/G0 gnd 21.815f
C23 p_cn/G1 gnd 21.5935f
C24 p_dc01/G1 gnd 15.7368f
C25 p1a gnd 25.3245f
.ends
