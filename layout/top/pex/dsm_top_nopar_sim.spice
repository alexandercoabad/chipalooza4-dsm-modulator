* dsm_top, extracted devices only (the same layout, no wiring capacitance): control for the parasitic comparison
.subckt dsm_top_pex vdda gnd clk vin vrp vrn vcm q qb g out
X0 vcm_replica_0/mn/S vcm vcm gnd sky130_fd_pr__nfet_g5v0d10v5 ad=1.16 pd=8.58 as=1.16 ps=8.58 w=4 l=2
X1 vcm_replica_0/mp/B vcm vcm vcm_replica_0/mp/B sky130_fd_pr__pfet_g5v0d10v5 ad=0.464 pd=3.49 as=0.464 ps=3.49 w=3.2 l=2
X2 vcm_replica_0/mp/B vcm vcm vcm_replica_0/mp/B sky130_fd_pr__pfet_g5v0d10v5 ad=0.464 pd=3.49 as=0.928 ps=6.98 w=3.2 l=2
X3 vcm vcm vcm_replica_0/mp/B vcm_replica_0/mp/B sky130_fd_pr__pfet_g5v0d10v5 ad=0.464 pd=3.49 as=0.464 ps=3.49 w=3.2 l=2
X4 vcm vcm vcm_replica_0/mp/B vcm_replica_0/mp/B sky130_fd_pr__pfet_g5v0d10v5 ad=0.464 pd=3.49 as=0.464 ps=3.49 w=3.2 l=2
X5 vcm_replica_0/mp/B vcm vcm vcm_replica_0/mp/B sky130_fd_pr__pfet_g5v0d10v5 ad=0.928 pd=6.98 as=0.464 ps=3.49 w=3.2 l=2
X6 vcm_replica_0/mn/S vdda gnd gnd sky130_fd_pr__nfet_g5v0d10v5 ad=0.45385 pd=3.42 as=0.45385 ps=3.42 w=3.13 l=0.5
X7 gnd vdda vcm_replica_0/mn/S gnd sky130_fd_pr__nfet_g5v0d10v5 ad=0.45385 pd=3.42 as=0.9077 ps=6.84 w=3.13 l=0.5
X8 vcm_replica_0/mn/S vdda gnd gnd sky130_fd_pr__nfet_g5v0d10v5 ad=0.9077 pd=6.84 as=0.45385 ps=3.42 w=3.13 l=0.5
X9 gnd vdda vcm_replica_0/mn/S gnd sky130_fd_pr__nfet_g5v0d10v5 ad=0.45385 pd=3.42 as=0.45385 ps=3.42 w=3.13 l=0.5
X10 vdda gnd vcm_replica_0/mp/B vdda sky130_fd_pr__pfet_g5v0d10v5 ad=0.54375 pd=4.04 as=0.54375 ps=4.04 w=3.75 l=0.5
X11 vdda gnd vcm_replica_0/mp/B vdda sky130_fd_pr__pfet_g5v0d10v5 ad=0.54375 pd=4.04 as=0.54375 ps=4.04 w=3.75 l=0.5
X12 vdda gnd vcm_replica_0/mp/B vdda sky130_fd_pr__pfet_g5v0d10v5 ad=0.54375 pd=4.04 as=1.0875 ps=8.08 w=3.75 l=0.5
X13 vcm_replica_0/mp/B gnd vdda vdda sky130_fd_pr__pfet_g5v0d10v5 ad=0.54375 pd=4.04 as=0.54375 ps=4.04 w=3.75 l=0.5
X14 vcm_replica_0/mp/B gnd vdda vdda sky130_fd_pr__pfet_g5v0d10v5 ad=1.0875 pd=8.08 as=0.54375 ps=4.04 w=3.75 l=0.5
X15 vdda gnd vcm_replica_0/mp/B vdda sky130_fd_pr__pfet_g5v0d10v5 ad=0.54375 pd=4.04 as=0.54375 ps=4.04 w=3.75 l=0.5
X16 vdda gnd vcm_replica_0/mp/B vdda sky130_fd_pr__pfet_g5v0d10v5 ad=0.54375 pd=4.04 as=0.54375 ps=4.04 w=3.75 l=0.5
X17 vcm_replica_0/mp/B gnd vdda vdda sky130_fd_pr__pfet_g5v0d10v5 ad=0.54375 pd=4.04 as=0.54375 ps=4.04 w=3.75 l=0.5
X18 vcm_replica_0/mp/B gnd vdda vdda sky130_fd_pr__pfet_g5v0d10v5 ad=0.54375 pd=4.04 as=0.54375 ps=4.04 w=3.75 l=0.5
X19 vcm_replica_0/mp/B gnd vdda vdda sky130_fd_pr__pfet_g5v0d10v5 ad=0.54375 pd=4.04 as=0.54375 ps=4.04 w=3.75 l=0.5
X20 clkgen_0/p_dc23/G0 gnd sky130_fd_pr__cap_mim_m3_1 l=5.32 w=5.32
X21 vdda clkgen_0/p_a1/D clkgen_0/p1a vdda sky130_fd_pr__pfet_g5v0d10v5 ad=1.74 pd=12.29 as=3.48 ps=24.58 w=12 l=0.5
X22 clkgen_0/p1a clkgen_0/p_a1/D vdda vdda sky130_fd_pr__pfet_g5v0d10v5 ad=3.48 pd=24.58 as=1.74 ps=12.29 w=12 l=0.5
X23 vdda clkgen_0/p_a1/G clkgen_0/p_a1/D vdda sky130_fd_pr__pfet_g5v0d10v5 ad=3.48 pd=24.58 as=3.48 ps=24.58 w=12 l=0.5
X24 vdda clkgen_0/p_b1/D clkgen_0/p2 vdda sky130_fd_pr__pfet_g5v0d10v5 ad=112.1575 pd=810.03998 as=6.96 ps=49.16 w=12 l=0.5
X25 clkgen_0/p2 clkgen_0/p_b1/D vdda vdda sky130_fd_pr__pfet_g5v0d10v5 ad=0 pd=0 as=0 ps=0 w=12 l=0.5
X26 vdda clkgen_0/p2 clkgen_0/p2b vdda sky130_fd_pr__pfet_g5v0d10v5 ad=0 pd=0 as=6.96 ps=49.16 w=12 l=0.5
X27 clkgen_0/p2b clkgen_0/p2 vdda vdda sky130_fd_pr__pfet_g5v0d10v5 ad=0 pd=0 as=0 ps=0 w=12 l=0.5
X28 vdda clkgen_0/p2 clkgen_0/p_dg2/G1 vdda sky130_fd_pr__pfet_g5v0d10v5 ad=0.29 pd=2.29 as=0.58 ps=4.58 w=2 l=4
X29 clkgen_0/p_n1/G1 clkgen_0/p_dg2/G1 vdda vdda sky130_fd_pr__pfet_g5v0d10v5 ad=0.58 pd=4.58 as=0.29 ps=2.29 w=2 l=4
X30 clkgen_0/p_dc23/G0 clkgen_0/p_dc01/G1 gnd gnd sky130_fd_pr__nfet_g5v0d10v5 ad=0.29 pd=2.58 as=0.145 ps=1.29 w=1 l=4
X31 gnd clkgen_0/p1a clkgen_0/p_dc01/G1 gnd sky130_fd_pr__nfet_g5v0d10v5 ad=0.145 pd=1.29 as=0.29 ps=2.58 w=1 l=4
X32 clkgen_0/p_cn/G1 clkgen_0/p_dc23/G1 gnd gnd sky130_fd_pr__nfet_g5v0d10v5 ad=0.29 pd=2.58 as=46.4754 ps=343.72 w=1 l=4
X33 gnd clkgen_0/p_dc23/G0 clkgen_0/p_dc23/G1 gnd sky130_fd_pr__nfet_g5v0d10v5 ad=0 pd=0 as=0.29 ps=2.58 w=1 l=4
X34 vdda clkgen_0/p1a clkgen_0/p1ab vdda sky130_fd_pr__pfet_g5v0d10v5 ad=0 pd=0 as=6.96 ps=49.16 w=12 l=0.5
X35 clkgen_0/p1ab clkgen_0/p1a vdda vdda sky130_fd_pr__pfet_g5v0d10v5 ad=0 pd=0 as=0 ps=0 w=12 l=0.5
X36 clkgen_0/p_dc23/G1 gnd sky130_fd_pr__cap_mim_m3_1 l=5.32 w=5.32
X37 clkgen_0/p_cn/G1 gnd sky130_fd_pr__cap_mim_m3_1 l=5.32 w=5.32
X38 gnd clkgen_0/p_e1/G clkgen_0/p_e1/D gnd sky130_fd_pr__nfet_g5v0d10v5 ad=1.16 pd=8.58 as=1.16 ps=8.58 w=4 l=0.5
X39 gnd clkgen_0/p_e1/D clkgen_0/p1 gnd sky130_fd_pr__nfet_g5v0d10v5 ad=2.32 pd=16.58 as=2.32 ps=16.58 w=8 l=0.5
X40 gnd clkgen_0/p1 clkgen_0/p1b gnd sky130_fd_pr__nfet_g5v0d10v5 ad=0 pd=0 as=2.32 ps=16.58 w=8 l=0.5
X41 vdda clkgen_0/p_cb/G clkgen_0/cc vdda sky130_fd_pr__pfet_g5v0d10v5 ad=0 pd=0 as=3.48 ps=24.58 w=12 l=0.5
X42 gnd clkgen_0/p_b1/G clkgen_0/p_b1/D gnd sky130_fd_pr__nfet_g5v0d10v5 ad=0 pd=0 as=1.16 ps=8.58 w=4 l=0.5
X43 gnd clkgen_0/p_b1/D clkgen_0/p2 gnd sky130_fd_pr__nfet_g5v0d10v5 ad=0 pd=0 as=2.32 ps=16.58 w=8 l=0.5
X44 gnd clkgen_0/p_a1/G clkgen_0/p_a1/D gnd sky130_fd_pr__nfet_g5v0d10v5 ad=0 pd=0 as=1.16 ps=8.58 w=4 l=0.5
X45 vdda clkgen_0/p1a clkgen_0/p_de/G1 vdda sky130_fd_pr__pfet_g5v0d10v5 ad=0 pd=0 as=0.58 ps=4.58 w=2 l=4
X46 clkgen_0/p_e1/G clkgen_0/p_de/G1 vdda vdda sky130_fd_pr__pfet_g5v0d10v5 ad=0.58 pd=4.58 as=0 ps=0 w=2 l=4
X47 gnd clkgen_0/p_a1/D clkgen_0/p1a gnd sky130_fd_pr__nfet_g5v0d10v5 ad=0 pd=0 as=2.32 ps=16.58 w=8 l=0.5
X48 gnd clkgen_0/p2 clkgen_0/p2b gnd sky130_fd_pr__nfet_g5v0d10v5 ad=0 pd=0 as=2.32 ps=16.58 w=8 l=0.5
X49 vdda clkgen_0/p1a clkgen_0/p_dc01/G1 vdda sky130_fd_pr__pfet_g5v0d10v5 ad=0 pd=0 as=0.58 ps=4.58 w=2 l=4
X50 clkgen_0/p_dc23/G0 clkgen_0/p_dc01/G1 vdda vdda sky130_fd_pr__pfet_g5v0d10v5 ad=0.58 pd=4.58 as=0 ps=0 w=2 l=4
X51 vdda clkgen_0/p_dc23/G0 clkgen_0/p_dc23/G1 vdda sky130_fd_pr__pfet_g5v0d10v5 ad=0 pd=0 as=0.58 ps=4.58 w=2 l=4
X52 clkgen_0/p_cn/G1 clkgen_0/p_dc23/G1 vdda vdda sky130_fd_pr__pfet_g5v0d10v5 ad=0.58 pd=4.58 as=0 ps=0 w=2 l=4
X53 clkgen_0/p_dg2/G1 gnd sky130_fd_pr__cap_mim_m3_1 l=3 w=3
X54 gnd clkgen_0/p1a clkgen_0/p1ab gnd sky130_fd_pr__nfet_g5v0d10v5 ad=0 pd=0 as=2.32 ps=16.58 w=8 l=0.5
X55 clkgen_0/p_n1/G1 gnd sky130_fd_pr__cap_mim_m3_1 l=3 w=3
X56 vdda clk clkgen_0/p_ck/D vdda sky130_fd_pr__pfet_g5v0d10v5 ad=1.74 pd=12.58 as=1.74 ps=12.58 w=6 l=0.5
X57 clkgen_0/p_n2/G1 clkgen_0/p_dg1/G1 gnd gnd sky130_fd_pr__nfet_g5v0d10v5 ad=0.29 pd=2.58 as=0 ps=0 w=1 l=4
X58 gnd clkgen_0/p1 clkgen_0/p_dg1/G1 gnd sky130_fd_pr__nfet_g5v0d10v5 ad=0 pd=0 as=0.29 ps=2.58 w=1 l=4
X59 clkgen_0/p_n1/G1 clkgen_0/p_dg2/G1 gnd gnd sky130_fd_pr__nfet_g5v0d10v5 ad=0.29 pd=2.58 as=0 ps=0 w=1 l=4
X60 gnd clkgen_0/p2 clkgen_0/p_dg2/G1 gnd sky130_fd_pr__nfet_g5v0d10v5 ad=0 pd=0 as=0.29 ps=2.58 w=1 l=4
X61 clkgen_0/p_n1/S1 clkgen_0/p_ck/D vdda vdda sky130_fd_pr__pfet_g5v0d10v5 ad=3.48 pd=24.58 as=0 ps=0 w=12 l=0.5
X62 clkgen_0/p_a1/G clkgen_0/p_n1/G1 clkgen_0/p_n1/S1 vdda sky130_fd_pr__pfet_g5v0d10v5 ad=3.48 pd=24.58 as=0 ps=0 w=12 l=0.5
X63 vdda clkgen_0/p_cn/G1 clkgen_0/p_cb/G vdda sky130_fd_pr__pfet_g5v0d10v5 ad=1.74 pd=12.58 as=0.87 ps=6.29 w=6 l=0.5
X64 clkgen_0/p_cb/G clkgen_0/p1a vdda vdda sky130_fd_pr__pfet_g5v0d10v5 ad=0.87 pd=6.29 as=1.74 ps=12.58 w=6 l=0.5
X65 gnd clkgen_0/p_cb/G clkgen_0/cc gnd sky130_fd_pr__nfet_g5v0d10v5 ad=0 pd=0 as=1.16 ps=8.58 w=4 l=0.5
X66 clkgen_0/p_n2/S1 clk vdda vdda sky130_fd_pr__pfet_g5v0d10v5 ad=3.48 pd=24.58 as=0 ps=0 w=12 l=0.5
X67 clkgen_0/p_b1/G clkgen_0/p_n2/G1 clkgen_0/p_n2/S1 vdda sky130_fd_pr__pfet_g5v0d10v5 ad=3.48 pd=24.58 as=0 ps=0 w=12 l=0.5
X68 clkgen_0/p_e1/G clkgen_0/p_de/G1 gnd gnd sky130_fd_pr__nfet_g5v0d10v5 ad=0.29 pd=2.58 as=0 ps=0 w=1 l=4
X69 gnd clkgen_0/p1a clkgen_0/p_de/G1 gnd sky130_fd_pr__nfet_g5v0d10v5 ad=0 pd=0 as=0.29 ps=2.58 w=1 l=4
X70 vdda clkgen_0/p_e1/G clkgen_0/p_e1/D vdda sky130_fd_pr__pfet_g5v0d10v5 ad=0 pd=0 as=3.48 ps=24.58 w=12 l=0.5
X71 clkgen_0/p_de/G1 gnd sky130_fd_pr__cap_mim_m3_1 l=3 w=3
X72 gnd clk clkgen_0/p_ck/D gnd sky130_fd_pr__nfet_g5v0d10v5 ad=0.58 pd=4.58 as=0.58 ps=4.58 w=2 l=0.5
X73 clkgen_0/p_e1/G gnd sky130_fd_pr__cap_mim_m3_1 l=3 w=3
X74 vdda clkgen_0/p_e1/D clkgen_0/p1 vdda sky130_fd_pr__pfet_g5v0d10v5 ad=0 pd=0 as=6.96 ps=49.16 w=12 l=0.5
X75 clkgen_0/p1 clkgen_0/p_e1/D vdda vdda sky130_fd_pr__pfet_g5v0d10v5 ad=0 pd=0 as=0 ps=0 w=12 l=0.5
X76 clkgen_0/p_dg1/G1 gnd sky130_fd_pr__cap_mim_m3_1 l=3 w=3
X77 clkgen_0/p_n2/G1 gnd sky130_fd_pr__cap_mim_m3_1 l=3 w=3
X78 vdda clkgen_0/p1 clkgen_0/p1b vdda sky130_fd_pr__pfet_g5v0d10v5 ad=0 pd=0 as=6.96 ps=49.16 w=12 l=0.5
X79 clkgen_0/p1b clkgen_0/p1 vdda vdda sky130_fd_pr__pfet_g5v0d10v5 ad=0 pd=0 as=0 ps=0 w=12 l=0.5
X80 gnd clkgen_0/p_n1/G1 clkgen_0/p_a1/G gnd sky130_fd_pr__nfet_g5v0d10v5 ad=0.58 pd=4.58 as=0.29 ps=2.29 w=2 l=0.5
X81 clkgen_0/p_a1/G clkgen_0/p_ck/D gnd gnd sky130_fd_pr__nfet_g5v0d10v5 ad=0.29 pd=2.29 as=0.58 ps=4.58 w=2 l=0.5
X82 clkgen_0/n_cn/S1 clkgen_0/p1a clkgen_0/p_cb/G gnd sky130_fd_pr__nfet_g5v0d10v5 ad=0.58 pd=4.29 as=1.16 ps=8.58 w=4 l=0.5
X83 gnd clkgen_0/p_cn/G1 clkgen_0/n_cn/S1 gnd sky130_fd_pr__nfet_g5v0d10v5 ad=1.16 pd=8.58 as=0.58 ps=4.29 w=4 l=0.5
X84 vdda clkgen_0/p1 clkgen_0/p_dg1/G1 vdda sky130_fd_pr__pfet_g5v0d10v5 ad=0 pd=0 as=0.58 ps=4.58 w=2 l=4
X85 clkgen_0/p_n2/G1 clkgen_0/p_dg1/G1 vdda vdda sky130_fd_pr__pfet_g5v0d10v5 ad=0.58 pd=4.58 as=0 ps=0 w=2 l=4
X86 vdda clkgen_0/p_b1/G clkgen_0/p_b1/D vdda sky130_fd_pr__pfet_g5v0d10v5 ad=0 pd=0 as=3.48 ps=24.58 w=12 l=0.5
X87 clkgen_0/p_dc01/G1 gnd sky130_fd_pr__cap_mim_m3_1 l=5.32 w=5.32
X88 gnd clkgen_0/p_n2/G1 clkgen_0/p_b1/G gnd sky130_fd_pr__nfet_g5v0d10v5 ad=0 pd=0 as=0.58 ps=4.58 w=2 l=0.5
X89 clkgen_0/p_b1/G clk gnd gnd sky130_fd_pr__nfet_g5v0d10v5 ad=0 pd=0 as=0 ps=0 w=2 l=0.5
X90 tg_x0p5_mf_4/b tg_x0p5_mf_5/b sky130_fd_pr__cap_mim_m3_1 l=22.2 w=22.2
X91 tg_x0p5_mf_4/b tg_x0p5_mf_5/b sky130_fd_pr__cap_mim_m3_1 l=22.2 w=22.2
X92 g out sky130_fd_pr__cap_mim_m3_1 l=22.2 w=22.2
X93 g out sky130_fd_pr__cap_mim_m3_1 l=22.2 w=22.2
X94 g out sky130_fd_pr__cap_mim_m3_1 l=22.2 w=22.2
X95 g out sky130_fd_pr__cap_mim_m3_1 l=22.2 w=22.2
X96 vdda comp_compact_0/p_b2/G1 q vdda sky130_fd_pr__pfet_g5v0d10v5 ad=1.74 pd=12.29 as=3.48 ps=24.58 w=12 l=0.5
X97 q comp_compact_0/p_b2/G1 vdda vdda sky130_fd_pr__pfet_g5v0d10v5 ad=3.48 pd=24.58 as=1.74 ps=12.29 w=12 l=0.5
X98 comp_compact_0/p_x/G0 clkgen_0/cc vdda vdda sky130_fd_pr__pfet_g5v0d10v5 ad=0.58 pd=4.58 as=0.29 ps=2.29 w=2 l=0.5
X99 vdda clkgen_0/cc comp_compact_0/p_x/G1 vdda sky130_fd_pr__pfet_g5v0d10v5 ad=0.29 pd=2.29 as=0.58 ps=4.58 w=2 l=0.5
X100 comp_compact_0/n_x4/S clkgen_0/cc vdda vdda sky130_fd_pr__pfet_g5v0d10v5 ad=0.58 pd=4.58 as=0 ps=0 w=2 l=0.5
X101 vdda clkgen_0/cc comp_compact_0/n_x3/S vdda sky130_fd_pr__pfet_g5v0d10v5 ad=0 pd=0 as=0.58 ps=4.58 w=2 l=0.5
X102 comp_compact_0/p_cs1/S1 comp_compact_0/p_cs1/G0 vdda vdda sky130_fd_pr__pfet_g5v0d10v5 ad=0.58 pd=4.29 as=1.16 ps=8.58 w=4 l=0.5
X103 comp_compact_0/p_b1/G1 comp_compact_0/p_b2/G1 comp_compact_0/p_cs1/S1 vdda sky130_fd_pr__pfet_g5v0d10v5 ad=1.16 pd=8.58 as=0.58 ps=4.29 w=4 l=0.5
X104 comp_compact_0/p_cs2/S1 comp_compact_0/p_iso/D0 vdda vdda sky130_fd_pr__pfet_g5v0d10v5 ad=1.16 pd=8.58 as=0 ps=0 w=4 l=0.5
X105 comp_compact_0/p_b2/G1 comp_compact_0/p_b1/G1 comp_compact_0/p_cs2/S1 vdda sky130_fd_pr__pfet_g5v0d10v5 ad=1.16 pd=8.58 as=0 ps=0 w=4 l=0.5
X106 comp_compact_0/p_cs1/G0 comp_compact_0/p_x/G0 gnd gnd sky130_fd_pr__nfet_g5v0d10v5 ad=0.29 pd=2.58 as=0.145 ps=1.29 w=1 l=0.5
X107 gnd comp_compact_0/p_x/G1 comp_compact_0/p_iso/D0 gnd sky130_fd_pr__nfet_g5v0d10v5 ad=0.145 pd=1.29 as=0.29 ps=2.58 w=1 l=0.5
X108 comp_compact_0/n_x4/S vcm comp_compact_0/n_tail/D gnd sky130_fd_pr__nfet_g5v0d10v5 ad=2.32 pd=16.58 as=1.16 ps=8.29 w=8 l=0.5
X109 comp_compact_0/n_tail/D out comp_compact_0/n_x3/S gnd sky130_fd_pr__nfet_g5v0d10v5 ad=1.16 pd=8.29 as=2.32 ps=16.58 w=8 l=0.5
X110 gnd clkgen_0/cc comp_compact_0/n_tail/D gnd sky130_fd_pr__nfet_g5v0d10v5 ad=2.32 pd=16.58 as=2.32 ps=16.58 w=8 l=0.5
X111 comp_compact_0/p_cs1/G0 comp_compact_0/p_x/G0 vdda vdda sky130_fd_pr__pfet_g5v0d10v5 ad=0.58 pd=4.58 as=0 ps=0 w=2 l=0.5
X112 vdda comp_compact_0/p_x/G1 comp_compact_0/p_iso/D0 vdda sky130_fd_pr__pfet_g5v0d10v5 ad=0 pd=0 as=0.58 ps=4.58 w=2 l=0.5
X113 comp_compact_0/p_x/G0 comp_compact_0/p_x/G1 vdda vdda sky130_fd_pr__pfet_g5v0d10v5 ad=2.32 pd=16.58 as=1.16 ps=8.29 w=8 l=0.5
X114 vdda comp_compact_0/p_x/G0 comp_compact_0/p_x/G1 vdda sky130_fd_pr__pfet_g5v0d10v5 ad=1.16 pd=8.29 as=2.32 ps=16.58 w=8 l=0.5
X115 comp_compact_0/n_x3/S comp_compact_0/p_x/G0 comp_compact_0/p_x/G1 gnd sky130_fd_pr__nfet_g5v0d10v5 ad=1.16 pd=8.58 as=1.16 ps=8.58 w=4 l=0.5
X116 q comp_compact_0/p_b2/G1 gnd gnd sky130_fd_pr__nfet_g5v0d10v5 ad=2.32 pd=16.58 as=0 ps=0 w=8 l=0.5
X117 gnd comp_compact_0/p_b1/G1 qb gnd sky130_fd_pr__nfet_g5v0d10v5 ad=0 pd=0 as=2.32 ps=16.58 w=8 l=0.5
X118 comp_compact_0/n_x4/S comp_compact_0/p_x/G1 comp_compact_0/p_x/G0 gnd sky130_fd_pr__nfet_g5v0d10v5 ad=3.48 pd=25.16 as=1.16 ps=8.58 w=4 l=0.5
X119 gnd comp_compact_0/p_b2/G1 comp_compact_0/p_b1/G1 gnd sky130_fd_pr__nfet_g5v0d10v5 ad=0 pd=0 as=0.29 ps=2.58 w=1 l=0.5
X120 comp_compact_0/p_b1/G1 comp_compact_0/p_cs1/G0 gnd gnd sky130_fd_pr__nfet_g5v0d10v5 ad=0 pd=0 as=0 ps=0 w=1 l=0.5
X121 gnd comp_compact_0/p_b1/G1 comp_compact_0/p_b2/G1 gnd sky130_fd_pr__nfet_g5v0d10v5 ad=0 pd=0 as=0.29 ps=2.58 w=1 l=0.5
X122 comp_compact_0/p_b2/G1 comp_compact_0/p_iso/D0 gnd gnd sky130_fd_pr__nfet_g5v0d10v5 ad=0 pd=0 as=0 ps=0 w=1 l=0.5
X123 vdda comp_compact_0/p_b1/G1 qb vdda sky130_fd_pr__pfet_g5v0d10v5 ad=0 pd=0 as=6.96 ps=49.16 w=12 l=0.5
X124 qb comp_compact_0/p_b1/G1 vdda vdda sky130_fd_pr__pfet_g5v0d10v5 ad=0 pd=0 as=0 ps=0 w=12 l=0.5
X125 tg_x0p5_mf_2/a qb vrn gnd sky130_fd_pr__nfet_g5v0d10v5 ad=1.16 pd=8.58 as=1.16 ps=8.58 w=4 l=0.5
X126 vrn q tg_x0p5_mf_2/a vdda sky130_fd_pr__pfet_g5v0d10v5 ad=0.58 pd=4.29 as=0.58 ps=4.29 w=4 l=0.5
X127 tg_x0p5_mf_2/a q vrn vdda sky130_fd_pr__pfet_g5v0d10v5 ad=0.58 pd=4.29 as=1.16 ps=8.58 w=4 l=0.5
X128 tg_x0p5_mf_2/a q vrn vdda sky130_fd_pr__pfet_g5v0d10v5 ad=1.16 pd=8.58 as=0.58 ps=4.29 w=4 l=0.5
X129 tg_x0p5_mf_2/a q vrp gnd sky130_fd_pr__nfet_g5v0d10v5 ad=3.48 pd=25.74 as=1.16 ps=8.58 w=4 l=0.5
X130 vrp qb tg_x0p5_mf_2/a vdda sky130_fd_pr__pfet_g5v0d10v5 ad=2.32 pd=17.16 as=6.96 ps=51.48 w=4 l=0.5
X131 tg_x0p5_mf_2/a qb vrp vdda sky130_fd_pr__pfet_g5v0d10v5 ad=0 pd=0 as=0 ps=0 w=4 l=0.5
X132 tg_x0p5_mf_2/a qb vrp vdda sky130_fd_pr__pfet_g5v0d10v5 ad=0 pd=0 as=0 ps=0 w=4 l=0.5
X133 g clkgen_0/p2 tg_x0p5_mf_4/b gnd sky130_fd_pr__nfet_g5v0d10v5 ad=1.16 pd=8.58 as=2.32 ps=17.16 w=4 l=0.5
X134 tg_x0p5_mf_4/b clkgen_0/p2b g vdda sky130_fd_pr__pfet_g5v0d10v5 ad=4.64 pd=34.32 as=2.32 ps=17.16 w=4 l=0.5
X135 g clkgen_0/p2b tg_x0p5_mf_4/b vdda sky130_fd_pr__pfet_g5v0d10v5 ad=0 pd=0 as=0 ps=0 w=4 l=0.5
X136 g clkgen_0/p2b tg_x0p5_mf_4/b vdda sky130_fd_pr__pfet_g5v0d10v5 ad=0 pd=0 as=0 ps=0 w=4 l=0.5
X137 tg_x0p5_mf_5/b clkgen_0/p2 tg_x0p5_mf_2/a gnd sky130_fd_pr__nfet_g5v0d10v5 ad=2.32 pd=17.16 as=0 ps=0 w=4 l=0.5
X138 tg_x0p5_mf_2/a clkgen_0/p2b tg_x0p5_mf_5/b vdda sky130_fd_pr__pfet_g5v0d10v5 ad=0 pd=0 as=4.64 ps=34.32 w=4 l=0.5
X139 tg_x0p5_mf_5/b clkgen_0/p2b tg_x0p5_mf_2/a vdda sky130_fd_pr__pfet_g5v0d10v5 ad=0 pd=0 as=0 ps=0 w=4 l=0.5
X140 tg_x0p5_mf_5/b clkgen_0/p2b tg_x0p5_mf_2/a vdda sky130_fd_pr__pfet_g5v0d10v5 ad=0 pd=0 as=0 ps=0 w=4 l=0.5
X141 tg_x0p5_mf_4/b clkgen_0/p1a vcm gnd sky130_fd_pr__nfet_g5v0d10v5 ad=0 pd=0 as=2.32 ps=17.16 w=4 l=0.5
X142 vcm clkgen_0/p1ab tg_x0p5_mf_4/b vdda sky130_fd_pr__pfet_g5v0d10v5 ad=5.104 pd=38.1 as=0 ps=0 w=4 l=0.5
X143 tg_x0p5_mf_4/b clkgen_0/p1ab vcm vdda sky130_fd_pr__pfet_g5v0d10v5 ad=0 pd=0 as=0 ps=0 w=4 l=0.5
X144 tg_x0p5_mf_4/b clkgen_0/p1ab vcm vdda sky130_fd_pr__pfet_g5v0d10v5 ad=0 pd=0 as=0 ps=0 w=4 l=0.5
X145 tg_x0p5_mf_5/b clkgen_0/p1 vin gnd sky130_fd_pr__nfet_g5v0d10v5 ad=0 pd=0 as=1.16 ps=8.58 w=4 l=0.5
X146 vin clkgen_0/p1b tg_x0p5_mf_5/b vdda sky130_fd_pr__pfet_g5v0d10v5 ad=2.32 pd=17.16 as=0 ps=0 w=4 l=0.5
X147 tg_x0p5_mf_5/b clkgen_0/p1b vin vdda sky130_fd_pr__pfet_g5v0d10v5 ad=0 pd=0 as=0 ps=0 w=4 l=0.5
X148 tg_x0p5_mf_5/b clkgen_0/p1b vin vdda sky130_fd_pr__pfet_g5v0d10v5 ad=0 pd=0 as=0 ps=0 w=4 l=0.5
X149 ota_core_0/mn/S7 g out gnd sky130_fd_pr__nfet_g5v0d10v5 ad=0.58 pd=4.29 as=0.58 ps=4.29 w=4 l=2
X150 ota_core_0/mn/S7 g out gnd sky130_fd_pr__nfet_g5v0d10v5 ad=0.58 pd=4.29 as=1.16 ps=8.58 w=4 l=2
X151 out g ota_core_0/mn/S7 gnd sky130_fd_pr__nfet_g5v0d10v5 ad=0.58 pd=4.29 as=0.58 ps=4.29 w=4 l=2
X152 ota_core_0/mn/S7 g out gnd sky130_fd_pr__nfet_g5v0d10v5 ad=0.58 pd=4.29 as=0.58 ps=4.29 w=4 l=2
X153 out g ota_core_0/mn/S7 gnd sky130_fd_pr__nfet_g5v0d10v5 ad=0.58 pd=4.29 as=0.58 ps=4.29 w=4 l=2
X154 ota_core_0/mn/S7 g out gnd sky130_fd_pr__nfet_g5v0d10v5 ad=0.58 pd=4.29 as=0.58 ps=4.29 w=4 l=2
X155 out g ota_core_0/mn/S7 gnd sky130_fd_pr__nfet_g5v0d10v5 ad=1.16 pd=8.58 as=0.58 ps=4.29 w=4 l=2
X156 out g ota_core_0/mn/S7 gnd sky130_fd_pr__nfet_g5v0d10v5 ad=0.58 pd=4.29 as=0.58 ps=4.29 w=4 l=2
X157 out g ota_core_0/mp/B ota_core_0/mp/B sky130_fd_pr__pfet_g5v0d10v5 ad=0.58 pd=4.29 as=0.58 ps=4.29 w=4 l=2
X158 ota_core_0/mp/B g out ota_core_0/mp/B sky130_fd_pr__pfet_g5v0d10v5 ad=0.58 pd=4.29 as=0.58 ps=4.29 w=4 l=2
X159 ota_core_0/mp/B g out ota_core_0/mp/B sky130_fd_pr__pfet_g5v0d10v5 ad=0.58 pd=4.29 as=0.58 ps=4.29 w=4 l=2
X160 out g ota_core_0/mp/B ota_core_0/mp/B sky130_fd_pr__pfet_g5v0d10v5 ad=0.58 pd=4.29 as=0.58 ps=4.29 w=4 l=2
X161 ota_core_0/mp/B g out ota_core_0/mp/B sky130_fd_pr__pfet_g5v0d10v5 ad=0.58 pd=4.29 as=0.58 ps=4.29 w=4 l=2
X162 ota_core_0/mp/B g out ota_core_0/mp/B sky130_fd_pr__pfet_g5v0d10v5 ad=0.58 pd=4.29 as=0.58 ps=4.29 w=4 l=2
X163 out g ota_core_0/mp/B ota_core_0/mp/B sky130_fd_pr__pfet_g5v0d10v5 ad=0.58 pd=4.29 as=0.58 ps=4.29 w=4 l=2
X164 out g ota_core_0/mp/B ota_core_0/mp/B sky130_fd_pr__pfet_g5v0d10v5 ad=0.58 pd=4.29 as=0.58 ps=4.29 w=4 l=2
X165 out g ota_core_0/mp/B ota_core_0/mp/B sky130_fd_pr__pfet_g5v0d10v5 ad=1.16 pd=8.58 as=0.58 ps=4.29 w=4 l=2
X166 out g ota_core_0/mp/B ota_core_0/mp/B sky130_fd_pr__pfet_g5v0d10v5 ad=0.58 pd=4.29 as=0.58 ps=4.29 w=4 l=2
X167 out g ota_core_0/mp/B ota_core_0/mp/B sky130_fd_pr__pfet_g5v0d10v5 ad=0.58 pd=4.29 as=0.58 ps=4.29 w=4 l=2
X168 out g ota_core_0/mp/B ota_core_0/mp/B sky130_fd_pr__pfet_g5v0d10v5 ad=0.58 pd=4.29 as=0.58 ps=4.29 w=4 l=2
X169 out g ota_core_0/mp/B ota_core_0/mp/B sky130_fd_pr__pfet_g5v0d10v5 ad=0.58 pd=4.29 as=0.58 ps=4.29 w=4 l=2
X170 ota_core_0/mp/B g out ota_core_0/mp/B sky130_fd_pr__pfet_g5v0d10v5 ad=0.58 pd=4.29 as=0.58 ps=4.29 w=4 l=2
X171 ota_core_0/mp/B g out ota_core_0/mp/B sky130_fd_pr__pfet_g5v0d10v5 ad=0.58 pd=4.29 as=0.58 ps=4.29 w=4 l=2
X172 ota_core_0/mp/B g out ota_core_0/mp/B sky130_fd_pr__pfet_g5v0d10v5 ad=0.58 pd=4.29 as=0.58 ps=4.29 w=4 l=2
X173 ota_core_0/mp/B g out ota_core_0/mp/B sky130_fd_pr__pfet_g5v0d10v5 ad=0.58 pd=4.29 as=0.58 ps=4.29 w=4 l=2
X174 out g ota_core_0/mp/B ota_core_0/mp/B sky130_fd_pr__pfet_g5v0d10v5 ad=0.58 pd=4.29 as=0.58 ps=4.29 w=4 l=2
X175 ota_core_0/mp/B g out ota_core_0/mp/B sky130_fd_pr__pfet_g5v0d10v5 ad=0.58 pd=4.29 as=0.58 ps=4.29 w=4 l=2
X176 ota_core_0/mp/B g out ota_core_0/mp/B sky130_fd_pr__pfet_g5v0d10v5 ad=0.58 pd=4.29 as=0.58 ps=4.29 w=4 l=2
X177 ota_core_0/mp/B g out ota_core_0/mp/B sky130_fd_pr__pfet_g5v0d10v5 ad=0.58 pd=4.29 as=0.58 ps=4.29 w=4 l=2
X178 out g ota_core_0/mp/B ota_core_0/mp/B sky130_fd_pr__pfet_g5v0d10v5 ad=0.58 pd=4.29 as=0.58 ps=4.29 w=4 l=2
X179 out g ota_core_0/mp/B ota_core_0/mp/B sky130_fd_pr__pfet_g5v0d10v5 ad=0.58 pd=4.29 as=0.58 ps=4.29 w=4 l=2
X180 ota_core_0/mp/B g out ota_core_0/mp/B sky130_fd_pr__pfet_g5v0d10v5 ad=0.58 pd=4.29 as=0.58 ps=4.29 w=4 l=2
X181 out g ota_core_0/mp/B ota_core_0/mp/B sky130_fd_pr__pfet_g5v0d10v5 ad=0.58 pd=4.29 as=0.58 ps=4.29 w=4 l=2
X182 ota_core_0/mp/B g out ota_core_0/mp/B sky130_fd_pr__pfet_g5v0d10v5 ad=0.58 pd=4.29 as=1.16 ps=8.58 w=4 l=2
X183 ota_core_0/mp/B g out ota_core_0/mp/B sky130_fd_pr__pfet_g5v0d10v5 ad=0.58 pd=4.29 as=0.58 ps=4.29 w=4 l=2
X184 out g ota_core_0/mp/B ota_core_0/mp/B sky130_fd_pr__pfet_g5v0d10v5 ad=0.58 pd=4.29 as=0.58 ps=4.29 w=4 l=2
X185 out g ota_core_0/mp/B ota_core_0/mp/B sky130_fd_pr__pfet_g5v0d10v5 ad=0.58 pd=4.29 as=0.58 ps=4.29 w=4 l=2
X186 out g ota_core_0/mp/B ota_core_0/mp/B sky130_fd_pr__pfet_g5v0d10v5 ad=0.58 pd=4.29 as=0.58 ps=4.29 w=4 l=2
X187 ota_core_0/mp/B g out ota_core_0/mp/B sky130_fd_pr__pfet_g5v0d10v5 ad=0.58 pd=4.29 as=0.58 ps=4.29 w=4 l=2
X188 ota_core_0/mp/B g out ota_core_0/mp/B sky130_fd_pr__pfet_g5v0d10v5 ad=0.58 pd=4.29 as=0.58 ps=4.29 w=4 l=2
X189 gnd vdda ota_core_0/mn/S7 gnd sky130_fd_pr__nfet_g5v0d10v5 ad=0.725 pd=5.29 as=0.725 ps=5.29 w=5 l=0.5
X190 ota_core_0/mn/S7 vdda gnd gnd sky130_fd_pr__nfet_g5v0d10v5 ad=0.725 pd=5.29 as=0.725 ps=5.29 w=5 l=0.5
X191 ota_core_0/mn/S7 vdda gnd gnd sky130_fd_pr__nfet_g5v0d10v5 ad=0.725 pd=5.29 as=0.725 ps=5.29 w=5 l=0.5
X192 gnd vdda ota_core_0/mn/S7 gnd sky130_fd_pr__nfet_g5v0d10v5 ad=0.725 pd=5.29 as=0.725 ps=5.29 w=5 l=0.5
X193 gnd vdda ota_core_0/mn/S7 gnd sky130_fd_pr__nfet_g5v0d10v5 ad=0.725 pd=5.29 as=0.725 ps=5.29 w=5 l=0.5
X194 ota_core_0/mn/S7 vdda gnd gnd sky130_fd_pr__nfet_g5v0d10v5 ad=0.725 pd=5.29 as=0.725 ps=5.29 w=5 l=0.5
X195 ota_core_0/mn/S7 vdda gnd gnd sky130_fd_pr__nfet_g5v0d10v5 ad=0.725 pd=5.29 as=0.725 ps=5.29 w=5 l=0.5
X196 gnd vdda ota_core_0/mn/S7 gnd sky130_fd_pr__nfet_g5v0d10v5 ad=0.725 pd=5.29 as=0.725 ps=5.29 w=5 l=0.5
X197 ota_core_0/mn/S7 vdda gnd gnd sky130_fd_pr__nfet_g5v0d10v5 ad=0.725 pd=5.29 as=0.725 ps=5.29 w=5 l=0.5
X198 gnd vdda ota_core_0/mn/S7 gnd sky130_fd_pr__nfet_g5v0d10v5 ad=0.725 pd=5.29 as=0.725 ps=5.29 w=5 l=0.5
X199 gnd vdda ota_core_0/mn/S7 gnd sky130_fd_pr__nfet_g5v0d10v5 ad=0.725 pd=5.29 as=0.725 ps=5.29 w=5 l=0.5
X200 gnd vdda ota_core_0/mn/S7 gnd sky130_fd_pr__nfet_g5v0d10v5 ad=0.725 pd=5.29 as=1.45 ps=10.58 w=5 l=0.5
X201 ota_core_0/mn/S7 vdda gnd gnd sky130_fd_pr__nfet_g5v0d10v5 ad=1.45 pd=10.58 as=0.725 ps=5.29 w=5 l=0.5
X202 ota_core_0/mn/S7 vdda gnd gnd sky130_fd_pr__nfet_g5v0d10v5 ad=0.725 pd=5.29 as=0.725 ps=5.29 w=5 l=0.5
X203 gnd vdda ota_core_0/mn/S7 gnd sky130_fd_pr__nfet_g5v0d10v5 ad=0.725 pd=5.29 as=0.725 ps=5.29 w=5 l=0.5
X204 gnd vdda ota_core_0/mn/S7 gnd sky130_fd_pr__nfet_g5v0d10v5 ad=0.725 pd=5.29 as=0.725 ps=5.29 w=5 l=0.5
X205 ota_core_0/mn/S7 vdda gnd gnd sky130_fd_pr__nfet_g5v0d10v5 ad=0.725 pd=5.29 as=0.725 ps=5.29 w=5 l=0.5
X206 ota_core_0/mn/S7 vdda gnd gnd sky130_fd_pr__nfet_g5v0d10v5 ad=0.725 pd=5.29 as=0.725 ps=5.29 w=5 l=0.5
X207 gnd vdda ota_core_0/mn/S7 gnd sky130_fd_pr__nfet_g5v0d10v5 ad=0.725 pd=5.29 as=0.725 ps=5.29 w=5 l=0.5
X208 ota_core_0/mn/S7 vdda gnd gnd sky130_fd_pr__nfet_g5v0d10v5 ad=0.725 pd=5.29 as=0.725 ps=5.29 w=5 l=0.5
X209 vdda gnd ota_core_0/mp/B vdda sky130_fd_pr__pfet_g5v0d10v5 ad=0.725 pd=5.29 as=1.45 ps=10.58 w=5 l=0.5
X210 vdda gnd ota_core_0/mp/B vdda sky130_fd_pr__pfet_g5v0d10v5 ad=0.725 pd=5.29 as=0.725 ps=5.29 w=5 l=0.5
X211 ota_core_0/mp/B gnd vdda vdda sky130_fd_pr__pfet_g5v0d10v5 ad=0.725 pd=5.29 as=0.725 ps=5.29 w=5 l=0.5
X212 ota_core_0/mp/B gnd vdda vdda sky130_fd_pr__pfet_g5v0d10v5 ad=1.45 pd=10.58 as=0.725 ps=5.29 w=5 l=0.5
X213 vdda gnd ota_core_0/mp/B vdda sky130_fd_pr__pfet_g5v0d10v5 ad=0.725 pd=5.29 as=0.725 ps=5.29 w=5 l=0.5
X214 ota_core_0/mp/B gnd vdda vdda sky130_fd_pr__pfet_g5v0d10v5 ad=0.725 pd=5.29 as=0.725 ps=5.29 w=5 l=0.5
X215 ota_core_0/mp/B gnd vdda vdda sky130_fd_pr__pfet_g5v0d10v5 ad=0.725 pd=5.29 as=0.725 ps=5.29 w=5 l=0.5
X216 vdda gnd ota_core_0/mp/B vdda sky130_fd_pr__pfet_g5v0d10v5 ad=0.725 pd=5.29 as=0.725 ps=5.29 w=5 l=0.5
X217 ota_core_0/mp/B gnd vdda vdda sky130_fd_pr__pfet_g5v0d10v5 ad=0.725 pd=5.29 as=0.725 ps=5.29 w=5 l=0.5
X218 vdda gnd ota_core_0/mp/B vdda sky130_fd_pr__pfet_g5v0d10v5 ad=0.725 pd=5.29 as=0.725 ps=5.29 w=5 l=0.5
X219 vdda gnd ota_core_0/mp/B vdda sky130_fd_pr__pfet_g5v0d10v5 ad=0.725 pd=5.29 as=0.725 ps=5.29 w=5 l=0.5
X220 ota_core_0/mp/B gnd vdda vdda sky130_fd_pr__pfet_g5v0d10v5 ad=0.725 pd=5.29 as=0.725 ps=5.29 w=5 l=0.5
X221 ota_core_0/mp/B gnd vdda vdda sky130_fd_pr__pfet_g5v0d10v5 ad=0.725 pd=5.29 as=0.725 ps=5.29 w=5 l=0.5
X222 vdda gnd ota_core_0/mp/B vdda sky130_fd_pr__pfet_g5v0d10v5 ad=0.725 pd=5.29 as=0.725 ps=5.29 w=5 l=0.5
X223 ota_core_0/mp/B gnd vdda vdda sky130_fd_pr__pfet_g5v0d10v5 ad=0.725 pd=5.29 as=0.725 ps=5.29 w=5 l=0.5
X224 vdda gnd ota_core_0/mp/B vdda sky130_fd_pr__pfet_g5v0d10v5 ad=0.725 pd=5.29 as=0.725 ps=5.29 w=5 l=0.5
X225 ota_core_0/mp/B gnd vdda vdda sky130_fd_pr__pfet_g5v0d10v5 ad=0.725 pd=5.29 as=0.725 ps=5.29 w=5 l=0.5
X226 vdda gnd ota_core_0/mp/B vdda sky130_fd_pr__pfet_g5v0d10v5 ad=0.725 pd=5.29 as=0.725 ps=5.29 w=5 l=0.5
X227 vdda gnd ota_core_0/mp/B vdda sky130_fd_pr__pfet_g5v0d10v5 ad=0.725 pd=5.29 as=0.725 ps=5.29 w=5 l=0.5
X228 vdda gnd ota_core_0/mp/B vdda sky130_fd_pr__pfet_g5v0d10v5 ad=0.725 pd=5.29 as=0.725 ps=5.29 w=5 l=0.5
X229 ota_core_0/mp/B gnd vdda vdda sky130_fd_pr__pfet_g5v0d10v5 ad=0.725 pd=5.29 as=0.725 ps=5.29 w=5 l=0.5
X230 ota_core_0/mp/B gnd vdda vdda sky130_fd_pr__pfet_g5v0d10v5 ad=0.725 pd=5.29 as=0.725 ps=5.29 w=5 l=0.5
X231 vdda gnd ota_core_0/mp/B vdda sky130_fd_pr__pfet_g5v0d10v5 ad=0.725 pd=5.29 as=0.725 ps=5.29 w=5 l=0.5
X232 ota_core_0/mp/B gnd vdda vdda sky130_fd_pr__pfet_g5v0d10v5 ad=0.725 pd=5.29 as=0.725 ps=5.29 w=5 l=0.5
X233 vdda gnd ota_core_0/mp/B vdda sky130_fd_pr__pfet_g5v0d10v5 ad=0.725 pd=5.29 as=0.725 ps=5.29 w=5 l=0.5
X234 ota_core_0/mp/B gnd vdda vdda sky130_fd_pr__pfet_g5v0d10v5 ad=0.725 pd=5.29 as=0.725 ps=5.29 w=5 l=0.5
X235 vdda gnd ota_core_0/mp/B vdda sky130_fd_pr__pfet_g5v0d10v5 ad=0.725 pd=5.29 as=0.725 ps=5.29 w=5 l=0.5
X236 ota_core_0/mp/B gnd vdda vdda sky130_fd_pr__pfet_g5v0d10v5 ad=0.725 pd=5.29 as=0.725 ps=5.29 w=5 l=0.5
X237 vdda gnd ota_core_0/mp/B vdda sky130_fd_pr__pfet_g5v0d10v5 ad=0.725 pd=5.29 as=0.725 ps=5.29 w=5 l=0.5
X238 vdda gnd ota_core_0/mp/B vdda sky130_fd_pr__pfet_g5v0d10v5 ad=0.725 pd=5.29 as=0.725 ps=5.29 w=5 l=0.5
X239 ota_core_0/mp/B gnd vdda vdda sky130_fd_pr__pfet_g5v0d10v5 ad=0.725 pd=5.29 as=0.725 ps=5.29 w=5 l=0.5
X240 ota_core_0/mp/B gnd vdda vdda sky130_fd_pr__pfet_g5v0d10v5 ad=0.725 pd=5.29 as=0.725 ps=5.29 w=5 l=0.5
X241 vdda gnd ota_core_0/mp/B vdda sky130_fd_pr__pfet_g5v0d10v5 ad=0.725 pd=5.29 as=0.725 ps=5.29 w=5 l=0.5
X242 ota_core_0/mp/B gnd vdda vdda sky130_fd_pr__pfet_g5v0d10v5 ad=0.725 pd=5.29 as=0.725 ps=5.29 w=5 l=0.5
X243 vdda gnd ota_core_0/mp/B vdda sky130_fd_pr__pfet_g5v0d10v5 ad=0.725 pd=5.29 as=0.725 ps=5.29 w=5 l=0.5
X244 vdda gnd ota_core_0/mp/B vdda sky130_fd_pr__pfet_g5v0d10v5 ad=0.725 pd=5.29 as=0.725 ps=5.29 w=5 l=0.5
X245 ota_core_0/mp/B gnd vdda vdda sky130_fd_pr__pfet_g5v0d10v5 ad=0.725 pd=5.29 as=0.725 ps=5.29 w=5 l=0.5
X246 vdda gnd ota_core_0/mp/B vdda sky130_fd_pr__pfet_g5v0d10v5 ad=0.725 pd=5.29 as=0.725 ps=5.29 w=5 l=0.5
X247 ota_core_0/mp/B gnd vdda vdda sky130_fd_pr__pfet_g5v0d10v5 ad=0.725 pd=5.29 as=0.725 ps=5.29 w=5 l=0.5
X248 vdda gnd ota_core_0/mp/B vdda sky130_fd_pr__pfet_g5v0d10v5 ad=0.725 pd=5.29 as=0.725 ps=5.29 w=5 l=0.5
X249 ota_core_0/mp/B gnd vdda vdda sky130_fd_pr__pfet_g5v0d10v5 ad=0.725 pd=5.29 as=0.725 ps=5.29 w=5 l=0.5
X250 ota_core_0/mp/B gnd vdda vdda sky130_fd_pr__pfet_g5v0d10v5 ad=0.725 pd=5.29 as=0.725 ps=5.29 w=5 l=0.5
X251 ota_core_0/mp/B gnd vdda vdda sky130_fd_pr__pfet_g5v0d10v5 ad=0.725 pd=5.29 as=0.725 ps=5.29 w=5 l=0.5
X252 vdda gnd ota_core_0/mp/B vdda sky130_fd_pr__pfet_g5v0d10v5 ad=0.725 pd=5.29 as=0.725 ps=5.29 w=5 l=0.5
X253 ota_core_0/mp/B gnd vdda vdda sky130_fd_pr__pfet_g5v0d10v5 ad=0.725 pd=5.29 as=0.725 ps=5.29 w=5 l=0.5
X254 ota_core_0/mp/B gnd vdda vdda sky130_fd_pr__pfet_g5v0d10v5 ad=0.725 pd=5.29 as=0.725 ps=5.29 w=5 l=0.5
X255 vdda gnd ota_core_0/mp/B vdda sky130_fd_pr__pfet_g5v0d10v5 ad=0.725 pd=5.29 as=0.725 ps=5.29 w=5 l=0.5
X256 vdda gnd ota_core_0/mp/B vdda sky130_fd_pr__pfet_g5v0d10v5 ad=0.725 pd=5.29 as=0.725 ps=5.29 w=5 l=0.5
X257 vdda gnd ota_core_0/mp/B vdda sky130_fd_pr__pfet_g5v0d10v5 ad=0.725 pd=5.29 as=0.725 ps=5.29 w=5 l=0.5
X258 ota_core_0/mp/B gnd vdda vdda sky130_fd_pr__pfet_g5v0d10v5 ad=0.725 pd=5.29 as=0.725 ps=5.29 w=5 l=0.5
X259 ota_core_0/mp/B gnd vdda vdda sky130_fd_pr__pfet_g5v0d10v5 ad=0.725 pd=5.29 as=0.725 ps=5.29 w=5 l=0.5
X260 ota_core_0/mp/B gnd vdda vdda sky130_fd_pr__pfet_g5v0d10v5 ad=0.725 pd=5.29 as=0.725 ps=5.29 w=5 l=0.5
X261 vdda gnd ota_core_0/mp/B vdda sky130_fd_pr__pfet_g5v0d10v5 ad=0.725 pd=5.29 as=0.725 ps=5.29 w=5 l=0.5
X262 vdda gnd ota_core_0/mp/B vdda sky130_fd_pr__pfet_g5v0d10v5 ad=0.725 pd=5.29 as=0.725 ps=5.29 w=5 l=0.5
X263 vdda gnd ota_core_0/mp/B vdda sky130_fd_pr__pfet_g5v0d10v5 ad=0.725 pd=5.29 as=0.725 ps=5.29 w=5 l=0.5
X264 ota_core_0/mp/B gnd vdda vdda sky130_fd_pr__pfet_g5v0d10v5 ad=0.725 pd=5.29 as=0.725 ps=5.29 w=5 l=0.5
X265 ota_core_0/mp/B gnd vdda vdda sky130_fd_pr__pfet_g5v0d10v5 ad=0.725 pd=5.29 as=0.725 ps=5.29 w=5 l=0.5
X266 vdda gnd ota_core_0/mp/B vdda sky130_fd_pr__pfet_g5v0d10v5 ad=0.725 pd=5.29 as=0.725 ps=5.29 w=5 l=0.5
X267 vdda gnd ota_core_0/mp/B vdda sky130_fd_pr__pfet_g5v0d10v5 ad=0.725 pd=5.29 as=0.725 ps=5.29 w=5 l=0.5
X268 ota_core_0/mp/B gnd vdda vdda sky130_fd_pr__pfet_g5v0d10v5 ad=0.725 pd=5.29 as=0.725 ps=5.29 w=5 l=0.5
.ends
