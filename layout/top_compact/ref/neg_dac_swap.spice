* dsm_top: first-order switched-capacitor delta-sigma modulator, generated by gen_top_sch.py from topdef.py
* top-level ports: vdda gnd clk vin vrp vrn vcm q qb g out

* ---- block clkgen (clkgen/clkgen_sch.spice) ----
* Clock generator reference: analog/cells.py clockgen('g','clk') as simulated; ideal delay capacitors replaced by cap_mim_m3_1 (sizes from cap_size.py)
.subckt clkgen clk p1a p1ab p1 p1b p2 p2b cc vdda gnd
Xgckn_0 gclkb clk gnd gnd sky130_fd_pr__nfet_g5v0d10v5 w=2.0000 l=0.5 nf=1
Xgckp_0 gclkb clk vdda vdda sky130_fd_pr__pfet_g5v0d10v5 w=6.0000 l=0.5 nf=1
Xgn1na_0 gp1r gclkb gnd gnd sky130_fd_pr__nfet_g5v0d10v5 w=2.0000 l=0.5 nf=1
Xgn1nb_0 gp1r gp2d gnd gnd sky130_fd_pr__nfet_g5v0d10v5 w=2.0000 l=0.5 nf=1
Xgn1pa_0 gn1_m gclkb vdda vdda sky130_fd_pr__pfet_g5v0d10v5 w=12.0000 l=0.5 nf=1
Xgn1pb_0 gp1r gp2d gn1_m vdda sky130_fd_pr__pfet_g5v0d10v5 w=12.0000 l=0.5 nf=1
Xgn2na_0 gp2r clk gnd gnd sky130_fd_pr__nfet_g5v0d10v5 w=2.0000 l=0.5 nf=1
Xgn2nb_0 gp2r gp1d gnd gnd sky130_fd_pr__nfet_g5v0d10v5 w=2.0000 l=0.5 nf=1
Xgn2pa_0 gn2_m clk vdda vdda sky130_fd_pr__pfet_g5v0d10v5 w=12.0000 l=0.5 nf=1
Xgn2pb_0 gp2r gp1d gn2_m vdda sky130_fd_pr__pfet_g5v0d10v5 w=12.0000 l=0.5 nf=1
Xgdg1i0n_0 gdg1_d0 p1 gnd gnd sky130_fd_pr__nfet_g5v0d10v5 w=1.0000 l=4.0 nf=1
Xgdg1i0p_0 gdg1_d0 p1 vdda vdda sky130_fd_pr__pfet_g5v0d10v5 w=2.0000 l=4.0 nf=1
XCgdg1_0 gdg1_d0 gnd sky130_fd_pr__cap_mim_m3_1 w=3.0 l=3.0
Xgdg1i1n_0 gp1d gdg1_d0 gnd gnd sky130_fd_pr__nfet_g5v0d10v5 w=1.0000 l=4.0 nf=1
Xgdg1i1p_0 gp1d gdg1_d0 vdda vdda sky130_fd_pr__pfet_g5v0d10v5 w=2.0000 l=4.0 nf=1
XCgdg1_1 gp1d gnd sky130_fd_pr__cap_mim_m3_1 w=3.0 l=3.0
Xgdg2i0n_0 gdg2_d0 p2 gnd gnd sky130_fd_pr__nfet_g5v0d10v5 w=1.0000 l=4.0 nf=1
Xgdg2i0p_0 gdg2_d0 p2 vdda vdda sky130_fd_pr__pfet_g5v0d10v5 w=2.0000 l=4.0 nf=1
XCgdg2_0 gdg2_d0 gnd sky130_fd_pr__cap_mim_m3_1 w=3.0 l=3.0
Xgdg2i1n_0 gp2d gdg2_d0 gnd gnd sky130_fd_pr__nfet_g5v0d10v5 w=1.0000 l=4.0 nf=1
Xgdg2i1p_0 gp2d gdg2_d0 vdda vdda sky130_fd_pr__pfet_g5v0d10v5 w=2.0000 l=4.0 nf=1
XCgdg2_1 gp2d gnd sky130_fd_pr__cap_mim_m3_1 w=3.0 l=3.0
Xga1n_0 gp1an gp1r gnd gnd sky130_fd_pr__nfet_g5v0d10v5 w=4.0000 l=0.5 nf=1
Xga1p_0 gp1an gp1r vdda vdda sky130_fd_pr__pfet_g5v0d10v5 w=12.0000 l=0.5 nf=1
Xga2n_0 p1a gp1an gnd gnd sky130_fd_pr__nfet_g5v0d10v5 w=8.0000 l=0.5 nf=1
Xga2p_0 p1a gp1an vdda vdda sky130_fd_pr__pfet_g5v0d10v5 w=12.0000 l=0.5 nf=1
Xga2p_1 p1a gp1an vdda vdda sky130_fd_pr__pfet_g5v0d10v5 w=12.0000 l=0.5 nf=1
Xga3n_0 p1ab p1a gnd gnd sky130_fd_pr__nfet_g5v0d10v5 w=8.0000 l=0.5 nf=1
Xga3p_0 p1ab p1a vdda vdda sky130_fd_pr__pfet_g5v0d10v5 w=12.0000 l=0.5 nf=1
Xga3p_1 p1ab p1a vdda vdda sky130_fd_pr__pfet_g5v0d10v5 w=12.0000 l=0.5 nf=1
Xgdei0n_0 gde_d0 p1a gnd gnd sky130_fd_pr__nfet_g5v0d10v5 w=1.0000 l=4.0 nf=1
Xgdei0p_0 gde_d0 p1a vdda vdda sky130_fd_pr__pfet_g5v0d10v5 w=2.0000 l=4.0 nf=1
XCgde_0 gde_d0 gnd sky130_fd_pr__cap_mim_m3_1 w=3.0 l=3.0
Xgdei1n_0 gp1e gde_d0 gnd gnd sky130_fd_pr__nfet_g5v0d10v5 w=1.0000 l=4.0 nf=1
Xgdei1p_0 gp1e gde_d0 vdda vdda sky130_fd_pr__pfet_g5v0d10v5 w=2.0000 l=4.0 nf=1
XCgde_1 gp1e gnd sky130_fd_pr__cap_mim_m3_1 w=3.0 l=3.0
Xge1n_0 gp1en gp1e gnd gnd sky130_fd_pr__nfet_g5v0d10v5 w=4.0000 l=0.5 nf=1
Xge1p_0 gp1en gp1e vdda vdda sky130_fd_pr__pfet_g5v0d10v5 w=12.0000 l=0.5 nf=1
Xge2n_0 p1 gp1en gnd gnd sky130_fd_pr__nfet_g5v0d10v5 w=8.0000 l=0.5 nf=1
Xge2p_0 p1 gp1en vdda vdda sky130_fd_pr__pfet_g5v0d10v5 w=12.0000 l=0.5 nf=1
Xge2p_1 p1 gp1en vdda vdda sky130_fd_pr__pfet_g5v0d10v5 w=12.0000 l=0.5 nf=1
Xge3n_0 p1b p1 gnd gnd sky130_fd_pr__nfet_g5v0d10v5 w=8.0000 l=0.5 nf=1
Xge3p_0 p1b p1 vdda vdda sky130_fd_pr__pfet_g5v0d10v5 w=12.0000 l=0.5 nf=1
Xge3p_1 p1b p1 vdda vdda sky130_fd_pr__pfet_g5v0d10v5 w=12.0000 l=0.5 nf=1
Xgb1n_0 gp2n gp2r gnd gnd sky130_fd_pr__nfet_g5v0d10v5 w=4.0000 l=0.5 nf=1
Xgb1p_0 gp2n gp2r vdda vdda sky130_fd_pr__pfet_g5v0d10v5 w=12.0000 l=0.5 nf=1
Xgb2n_0 p2 gp2n gnd gnd sky130_fd_pr__nfet_g5v0d10v5 w=8.0000 l=0.5 nf=1
Xgb2p_0 p2 gp2n vdda vdda sky130_fd_pr__pfet_g5v0d10v5 w=12.0000 l=0.5 nf=1
Xgb2p_1 p2 gp2n vdda vdda sky130_fd_pr__pfet_g5v0d10v5 w=12.0000 l=0.5 nf=1
Xgb3n_0 p2b p2 gnd gnd sky130_fd_pr__nfet_g5v0d10v5 w=8.0000 l=0.5 nf=1
Xgb3p_0 p2b p2 vdda vdda sky130_fd_pr__pfet_g5v0d10v5 w=12.0000 l=0.5 nf=1
Xgb3p_1 p2b p2 vdda vdda sky130_fd_pr__pfet_g5v0d10v5 w=12.0000 l=0.5 nf=1
Xgdci0n_0 gdc_d0 p1a gnd gnd sky130_fd_pr__nfet_g5v0d10v5 w=1.0000 l=4.0 nf=1
Xgdci0p_0 gdc_d0 p1a vdda vdda sky130_fd_pr__pfet_g5v0d10v5 w=2.0000 l=4.0 nf=1
XCgdc_0 gdc_d0 gnd sky130_fd_pr__cap_mim_m3_1 w=5.32 l=5.32
Xgdci1n_0 gdc_d1 gdc_d0 gnd gnd sky130_fd_pr__nfet_g5v0d10v5 w=1.0000 l=4.0 nf=1
Xgdci1p_0 gdc_d1 gdc_d0 vdda vdda sky130_fd_pr__pfet_g5v0d10v5 w=2.0000 l=4.0 nf=1
XCgdc_1 gdc_d1 gnd sky130_fd_pr__cap_mim_m3_1 w=5.32 l=5.32
Xgdci2n_0 gdc_d2 gdc_d1 gnd gnd sky130_fd_pr__nfet_g5v0d10v5 w=1.0000 l=4.0 nf=1
Xgdci2p_0 gdc_d2 gdc_d1 vdda vdda sky130_fd_pr__pfet_g5v0d10v5 w=2.0000 l=4.0 nf=1
XCgdc_2 gdc_d2 gnd sky130_fd_pr__cap_mim_m3_1 w=5.32 l=5.32
Xgdci3n_0 gp1c gdc_d2 gnd gnd sky130_fd_pr__nfet_g5v0d10v5 w=1.0000 l=4.0 nf=1
Xgdci3p_0 gp1c gdc_d2 vdda vdda sky130_fd_pr__pfet_g5v0d10v5 w=2.0000 l=4.0 nf=1
XCgdc_3 gp1c gnd sky130_fd_pr__cap_mim_m3_1 w=5.32 l=5.32
Xgcnna_0 gccn p1a gcn_m gnd sky130_fd_pr__nfet_g5v0d10v5 w=4.0000 l=0.5 nf=1
Xgcnnb_0 gcn_m gp1c gnd gnd sky130_fd_pr__nfet_g5v0d10v5 w=4.0000 l=0.5 nf=1
Xgcnpa_0 gccn p1a vdda vdda sky130_fd_pr__pfet_g5v0d10v5 w=6.0000 l=0.5 nf=1
Xgcnpb_0 gccn gp1c vdda vdda sky130_fd_pr__pfet_g5v0d10v5 w=6.0000 l=0.5 nf=1
Xgcbn_0 cc gccn gnd gnd sky130_fd_pr__nfet_g5v0d10v5 w=4.0000 l=0.5 nf=1
Xgcbp_0 cc gccn vdda vdda sky130_fd_pr__pfet_g5v0d10v5 w=12.0000 l=0.5 nf=1
.ends

* ---- block vcm_replica (vcm/vcm_replica_sch.spice) ----
* vcm replica: v2 core at 1/8 width, output tied to input (self-biased), header on (gate enb, tied to gnd by the top level), footer on (gate en, tied to vdda by the top level) -- dsm1/sim/dsm1.py
.subckt vcm_replica vcm vdda gnd en enb
XMhp rcp enb vdda vdda sky130_fd_pr__pfet_g5v0d10v5 w=37.5 l=0.5
XMp  vcm vcm rcp  rcp  sky130_fd_pr__pfet_g5v0d10v5 w=16 l=2
XMn  vcm vcm rcn  gnd  sky130_fd_pr__nfet_g5v0d10v5 w=4 l=2
XMhn rcn en gnd gnd  sky130_fd_pr__nfet_g5v0d10v5 w=12.5 l=0.5
.ends

* ---- block tg_x0p5_mf (tg_mf/tg_x0p5_mf_sch.spice) ----
* Schematic of the transmission gate, same devices and sizes as v2/sim/v2.py tg() at TG scale 0.5 (nfet 4/0.5, pfet 12/0.5, one device each, nf=1 as simulated)
.subckt tg_x0p5_mf a b en enb vdd vss
XMN a en b vss sky130_fd_pr__nfet_g5v0d10v5 w=4 l=0.5 nf=1
XMP a enb b vdd sky130_fd_pr__pfet_g5v0d10v5 w=12 l=0.5 nf=1
.ends

* ---- block cap_array (mim/cap_array_sch.spice) ----
* Cs = 2 units, Ci = 4 units, unit = sky130_fd_pr__cap_mim_m3_1 w=l=22.2 (1.00 pF typical), c0 = top plate (capm/metal4), c1 = bottom plate (metal3)
* Ci: top = g (the OTA input, virtual ground), bottom = ci_b (OTA output).  Cs: top = cs_t (switched to vcm / g in the modulator), bottom = cs_b (sampling/DAC side)
.subckt cap_array g cs_t cs_b ci_b
XCs0 cs_t cs_b sky130_fd_pr__cap_mim_m3_1 w=22.2 l=22.2
XCs1 cs_t cs_b sky130_fd_pr__cap_mim_m3_1 w=22.2 l=22.2
XCi0 g ci_b sky130_fd_pr__cap_mim_m3_1 w=22.2 l=22.2
XCi1 g ci_b sky130_fd_pr__cap_mim_m3_1 w=22.2 l=22.2
XCi2 g ci_b sky130_fd_pr__cap_mim_m3_1 w=22.2 l=22.2
XCi3 g ci_b sky130_fd_pr__cap_mim_m3_1 w=22.2 l=22.2
.ends

* ---- block ota_core (ota/ota_core_sch.spice) ----
* Reference netlist: same devices and sizes as v2/sim/v2.py core (L, WN, WP, HDR_W, FTR_W)
.subckt ota_core vdda gnd g out en enb
XMhp vcp enb vdda vdda sky130_fd_pr__pfet_g5v0d10v5 w=300 l=0.5
XMp  out g   vcp  vcp  sky130_fd_pr__pfet_g5v0d10v5 w=128 l=2
XMn  out g   vcn  gnd  sky130_fd_pr__nfet_g5v0d10v5 w=32  l=2
XMhn vcn en  gnd  gnd  sky130_fd_pr__nfet_g5v0d10v5 w=100 l=0.5
.ends

* ---- block comp_compact (comp_compact/comp_sch.spice) ----
* Comparator reference: analog/cells.py strongarm() as simulated (isolated NOR latch variant), 50 fF placeholder loads removed
.subckt comp inp inn clk q qb vdda gnd
Xcmt_0 ctail clk gnd gnd sky130_fd_pr__nfet_g5v0d10v5 w=8.0000 l=0.5 nf=1
Xcm1_0 cx1 inp ctail gnd sky130_fd_pr__nfet_g5v0d10v5 w=8.0000 l=0.5 nf=1
Xcm2_0 cx2 inn ctail gnd sky130_fd_pr__nfet_g5v0d10v5 w=8.0000 l=0.5 nf=1
Xcm3_0 con cop cx1 gnd sky130_fd_pr__nfet_g5v0d10v5 w=4.0000 l=0.5 nf=1
Xcm4_0 cop con cx2 gnd sky130_fd_pr__nfet_g5v0d10v5 w=4.0000 l=0.5 nf=1
Xcm5_0 con cop vdda vdda sky130_fd_pr__pfet_g5v0d10v5 w=8.0000 l=0.5 nf=1
Xcm6_0 cop con vdda vdda sky130_fd_pr__pfet_g5v0d10v5 w=8.0000 l=0.5 nf=1
Xcm7_0 con clk vdda vdda sky130_fd_pr__pfet_g5v0d10v5 w=2.0000 l=0.5 nf=1
Xcm8_0 cop clk vdda vdda sky130_fd_pr__pfet_g5v0d10v5 w=2.0000 l=0.5 nf=1
Xcm9_0 cx1 clk vdda vdda sky130_fd_pr__pfet_g5v0d10v5 w=2.0000 l=0.5 nf=1
Xcm10_0 cx2 clk vdda vdda sky130_fd_pr__pfet_g5v0d10v5 w=2.0000 l=0.5 nf=1
Xciso1n_0 conn con gnd gnd sky130_fd_pr__nfet_g5v0d10v5 w=1.0000 l=0.5 nf=1
Xciso1p_0 conn con vdda vdda sky130_fd_pr__pfet_g5v0d10v5 w=2.0000 l=0.5 nf=1
Xciso2n_0 copn cop gnd gnd sky130_fd_pr__nfet_g5v0d10v5 w=1.0000 l=0.5 nf=1
Xciso2p_0 copn cop vdda vdda sky130_fd_pr__pfet_g5v0d10v5 w=2.0000 l=0.5 nf=1
Xcs1na_0 cQ copn gnd gnd sky130_fd_pr__nfet_g5v0d10v5 w=1.0000 l=0.5 nf=1
Xcs1nb_0 cQ cQb gnd gnd sky130_fd_pr__nfet_g5v0d10v5 w=1.0000 l=0.5 nf=1
Xcs1pa_0 cs1_m copn vdda vdda sky130_fd_pr__pfet_g5v0d10v5 w=4.0000 l=0.5 nf=1
Xcs1pb_0 cQ cQb cs1_m vdda sky130_fd_pr__pfet_g5v0d10v5 w=4.0000 l=0.5 nf=1
Xcs2na_0 cQb conn gnd gnd sky130_fd_pr__nfet_g5v0d10v5 w=1.0000 l=0.5 nf=1
Xcs2nb_0 cQb cQ gnd gnd sky130_fd_pr__nfet_g5v0d10v5 w=1.0000 l=0.5 nf=1
Xcs2pa_0 cs2_m conn vdda vdda sky130_fd_pr__pfet_g5v0d10v5 w=4.0000 l=0.5 nf=1
Xcs2pb_0 cQb cQ cs2_m vdda sky130_fd_pr__pfet_g5v0d10v5 w=4.0000 l=0.5 nf=1
Xcb1n_0 qb cQ gnd gnd sky130_fd_pr__nfet_g5v0d10v5 w=8.0000 l=0.5 nf=1
Xcb1p_0 qb cQ vdda vdda sky130_fd_pr__pfet_g5v0d10v5 w=12.0000 l=0.5 nf=1
Xcb1p_1 qb cQ vdda vdda sky130_fd_pr__pfet_g5v0d10v5 w=12.0000 l=0.5 nf=1
Xcb2n_0 q cQb gnd gnd sky130_fd_pr__nfet_g5v0d10v5 w=8.0000 l=0.5 nf=1
Xcb2p_0 q cQb vdda vdda sky130_fd_pr__pfet_g5v0d10v5 w=12.0000 l=0.5 nf=1
Xcb2p_1 q cQb vdda vdda sky130_fd_pr__pfet_g5v0d10v5 w=12.0000 l=0.5 nf=1
.ends

* ---- top level ----
.subckt dsm_top vdda gnd clk vin vrp vrn vcm q qb g out
Xxclk clk p1a p1ab p1 p1b p2 p2b cc vdda gnd clkgen
Xxvcm vcm vdda gnd vdda gnd vcm_replica
Xxsin vin b p1 p1b vdda gnd tg_x0p5_mf
Xxst1 vcm t p1a p1ab vdda gnd tg_x0p5_mf
Xxst2 t g p2 p2b vdda gnd tg_x0p5_mf
Xxsb2 dac b p2 p2b vdda gnd tg_x0p5_mf
Xxdp vrp dac qb q vdda gnd tg_x0p5_mf
Xxdn vrn dac qb q vdda gnd tg_x0p5_mf
Xxcap g t b out cap_array
Xxota vdda gnd g out vdda gnd ota_core
Xxcmp out vcm cc q qb vdda gnd comp
.ends
